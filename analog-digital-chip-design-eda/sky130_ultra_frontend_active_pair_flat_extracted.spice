* NGSPICE file created from sky130_ultra_frontend_active_pair_flat.ext - technology: sky130A

.subckt sky130_ultra_frontend_active_pair_flat vss vdd sample_p sense_p clk_sample
+ vcm_reset clk_latch sense_n sample_n iso_tail_flat iso_p_flat iso_n_flat
X0 iso_tail_flat sense_n iso_n_flat VSUBS sky130_fd_pr__nfet_01v8 ad=3.12 pd=7.6 as=3.36 ps=8 w=1.2 l=0.6
X1 iso_p_flat sense_p iso_tail_flat VSUBS sky130_fd_pr__nfet_01v8 ad=3.36 pd=8 as=3.12 ps=7.6 w=1.2 l=0.6
C0 sense_p iso_p_flat 0.02157f
C1 sense_p ultra_sample_p_sense_p_region 1.79971f
C2 m1_11440_900# iso_n_flat 0.0015f
C3 sense_p sense_n 0.42691f
C4 vss symmetric_latch_clock_region 0.05101f
C5 vdd sample_n 0.17983f
C6 clk_sample symmetric_latch_clock_region 0.37954f
C7 vss sample_n 0.18668f
C8 iso_tail_flat m2_8900_1800# 0.34398f
C9 ultra_sample_p_sense_p_region symmetric_reset_region 0.00907f
C10 m2_8900_1800# iso_p_flat 0.41846f
C11 vdd sample_p 0.18668f
C12 sense_p sample_n 0.19026f
C13 sense_n m2_8900_1800# 0.04564f
C14 vss sample_p 0.18668f
C15 clk_latch ultra_sample_n_sense_n_region 0.01482f
C16 iso_tail_flat iso_p_flat 0.05749f
C17 clk_latch vcm_reset 0.125f
C18 iso_tail_flat sense_n 0.14768f
C19 sense_p sample_p 0.81576f
C20 symmetric_reset_region symmetric_latch_clock_region 0.04571f
C21 vss ultra_sample_n_sense_n_region 0.05867f
C22 vcm_reset vdd 0.22214f
C23 clk_latch vdd 0.22562f
C24 vss vcm_reset 0.23025f
C25 vcm_reset clk_sample 0.125f
C26 vss clk_latch 0.23373f
C27 sense_p ultra_sample_n_sense_n_region 0.15529f
C28 ultra_sample_p_sense_p_region symmetric_latch_clock_region 0.00907f
C29 m2_8900_1800# iso_n_flat 0.41846f
C30 sense_p vcm_reset 0.20659f
C31 sense_p clk_latch 0.20937f
C32 clk_sample vdd 0.22562f
C33 sense_n sample_n 0.80429f
C34 iso_tail_flat iso_n_flat 0.05717f
C35 vss clk_sample 0.23373f
C36 iso_n_flat iso_p_flat 0.00782f
C37 ultra_sample_p_sense_p_region sample_p 1.54805f
C38 sense_p vdd 1.03026f
C39 symmetric_reset_region ultra_sample_n_sense_n_region 0.00907f
C40 m2_8900_1800# m1_11440_900# 0.01113f
C41 sense_n iso_n_flat 0.02157f
C42 sense_p vss 0.19187f
C43 vcm_reset symmetric_reset_region 0.45911f
C44 sense_p clk_sample 0.20937f
C45 sense_p m1_9000_900# 0.04555f
C46 clk_latch symmetric_reset_region 0.37792f
C47 iso_tail_flat m1_11440_900# 0.0015f
C48 sense_n ultra_sample_n_sense_n_region 1.68641f
C49 sense_n m1_11440_900# 0.04555f
C50 clk_sample symmetric_reset_region 0.37792f
C51 m2_8900_1800# m1_9000_900# 0.01113f
C52 sense_p symmetric_reset_region 0.08585f
C53 ultra_sample_p_sense_p_region vdd 0.01564f
C54 symmetric_latch_clock_region ultra_sample_n_sense_n_region 0.00907f
C55 sense_p m2_8900_1800# 0.05059f
C56 iso_tail_flat m1_9000_900# 0.0015f
C57 ultra_sample_p_sense_p_region vss 0.05867f
C58 sense_n vdd 0.20824f
C59 ultra_sample_p_sense_p_region clk_sample 0.01482f
C60 iso_p_flat m1_9000_900# 0.0015f
C61 vcm_reset symmetric_latch_clock_region 0.46074f
C62 ultra_sample_n_sense_n_region sample_n 1.5412f
C63 clk_latch symmetric_latch_clock_region 0.37954f
C64 sense_n vss 0.19187f
C65 sense_p iso_tail_flat 0.15361f
C66 sample_n VSUBS 0.51538f
C67 clk_latch VSUBS 0.78545f
C68 vcm_reset VSUBS 0.49259f
C69 clk_sample VSUBS 0.78545f
C70 sample_p VSUBS 0.60102f
C71 vss VSUBS 3.15132f
C72 vdd VSUBS 2.51894f
C73 iso_n_flat VSUBS 3.09478f
C74 iso_p_flat VSUBS 3.01951f
C75 iso_tail_flat VSUBS 8.21783f
C76 m2_8900_1800# VSUBS 0.99613f ; **FLOATING
C77 m1_11440_900# VSUBS 0.31893f ; **FLOATING
C78 m1_9000_900# VSUBS 0.31893f ; **FLOATING
C79 ultra_sample_n_sense_n_region VSUBS 2.48755f ; **FLOATING
C80 symmetric_latch_clock_region VSUBS 0.96795f ; **FLOATING
C81 symmetric_reset_region VSUBS 0.91055f ; **FLOATING
C82 ultra_sample_p_sense_p_region VSUBS 2.50824f ; **FLOATING
.ends
