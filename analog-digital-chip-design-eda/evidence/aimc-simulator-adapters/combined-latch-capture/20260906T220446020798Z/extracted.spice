* NGSPICE file created from combined_latch_capture.ext - technology: sky130A

.subckt combined_latch_capture out_p out_n latch_sense_p latch_sense_n tail reset
+ vdd vss eval sense_p sense_n iso_tail vdd_active rx_p rx_n eq_reset capture_clk
+ captured_q vdd_capture
X0 vss a_1634_36159# a_1592_36047# vss sky130_fd_pr__nfet_01v8 ad=0.12095 pd=1.085 as=0.0696 ps=0.765 w=0.42 l=0.15
X1 rx_p out_p vss vss sky130_fd_pr__nfet_01v8 ad=0.1218 pd=1.42 as=0.1218 ps=1.42 w=0.42 l=0.15
X2 a_1561_36413# a_1027_36047# a_1466_36413# w_962_36261# sky130_fd_pr__pfet_01v8_hvt ad=0.07665 pd=0.785 as=0.06825 ps=0.745 w=0.42 l=0.15
X3 vdd_capture a_1634_36159# a_1561_36413# w_962_36261# sky130_fd_pr__pfet_01v8_hvt ad=0.17887 pd=1.26 as=0.07665 ps=0.785 w=0.42 l=0.15
X4 a_1891_36413# a_1027_36047# a_1634_36159# w_962_36261# sky130_fd_pr__pfet_01v8_hvt ad=0.0567 pd=0.69 as=0.1095 ps=1.075 w=0.42 l=0.15
X5 out_p out_n vdd_active vdd_active sky130_fd_pr__pfet_01v8 ad=6.72 pd=10.4 as=6.24 ps=10 w=2.4 l=0.6
X6 vss out_n rx_n vss sky130_fd_pr__nfet_01v8 ad=0.1218 pd=1.42 as=0.1218 ps=1.42 w=0.42 l=0.15
X7 vss a_1891_36413# a_2059_36315# vss sky130_fd_pr__nfet_01v8 ad=0.08775 pd=0.92 as=0.169 ps=1.82 w=0.65 l=0.15
X8 latch_sense_n eq_reset latch_sense_p vdd_active sky130_fd_pr__pfet_01v8 ad=3.24 pd=7.8 as=3.24 ps=7.8 w=1.2 l=0.6
X9 a_1975_36413# a_1193_36047# a_1891_36413# w_962_36261# sky130_fd_pr__pfet_01v8_hvt ad=0.0882 pd=0.84 as=0.0567 ps=0.69 w=0.42 l=0.15
X10 vdd reset out_n vdd sky130_fd_pr__pfet_01v8 ad=3.12 pd=7.6 as=3.36 ps=8 w=1.2 l=0.6
X11 captured_q a_2059_36315# vss vss sky130_fd_pr__nfet_01v8 ad=0.169 pd=1.82 as=0.08775 ps=0.92 w=0.65 l=0.15
X12 tail out_p out_n vss sky130_fd_pr__nfet_01v8 ad=3.12 pd=7.6 as=3.36 ps=8 w=1.2 l=0.6
X13 a_1634_36159# a_1466_36413# vdd_capture w_962_36261# sky130_fd_pr__pfet_01v8_hvt ad=0.1095 pd=1.075 as=0.17887 ps=1.26 w=0.75 l=0.15
X14 a_1891_36413# a_1193_36047# a_1634_36159# vss sky130_fd_pr__special_nfet_01v8 ad=0.0684 pd=0.74 as=0.0989 ps=0.995 w=0.36 l=0.15
X15 out_p reset vdd vdd sky130_fd_pr__pfet_01v8 ad=3.36 pd=8 as=3.12 ps=7.6 w=1.2 l=0.6
X16 a_2017_36047# a_1027_36047# a_1891_36413# vss sky130_fd_pr__special_nfet_01v8 ad=0.066 pd=0.745 as=0.0684 ps=0.74 w=0.36 l=0.15
X17 out_p out_n tail vss sky130_fd_pr__nfet_01v8 ad=3.36 pd=8 as=3.12 ps=7.6 w=1.2 l=0.6
X18 a_1381_36047# rx_n vss vss sky130_fd_pr__nfet_01v8 ad=0.0813 pd=0.83 as=0.1092 ps=1.36 w=0.42 l=0.15
X19 tail latch_sense_n out_n vss sky130_fd_pr__nfet_01v8 ad=3.12 pd=7.6 as=3.36 ps=8 w=1.2 l=0.6
X20 vdd_capture a_2059_36315# a_1975_36413# w_962_36261# sky130_fd_pr__pfet_01v8_hvt ad=0.1113 pd=1.37 as=0.0882 ps=0.84 w=0.42 l=0.15
X21 tail eval vss vss sky130_fd_pr__nfet_01v8 ad=16.2 pd=17.4 as=16.2 ps=17.4 w=6 l=0.6
X22 a_1466_36413# a_1193_36047# a_1381_36047# w_962_36261# sky130_fd_pr__pfet_01v8_hvt ad=0.06825 pd=0.745 as=0.05775 ps=0.695 w=0.42 l=0.15
X23 a_1466_36413# a_1027_36047# a_1381_36047# vss sky130_fd_pr__special_nfet_01v8 ad=0.0621 pd=0.705 as=0.0813 ps=0.83 w=0.36 l=0.15
X24 captured_q a_2059_36315# vdd_capture w_962_36261# sky130_fd_pr__pfet_01v8_hvt ad=0.26 pd=2.52 as=0.135 ps=1.27 w=1 l=0.15
X25 vdd_capture a_1891_36413# a_2059_36315# w_962_36261# sky130_fd_pr__pfet_01v8_hvt ad=0.135 pd=1.27 as=0.27 ps=2.54 w=1 l=0.15
X26 out_p latch_sense_p tail vss sky130_fd_pr__nfet_01v8 ad=3.36 pd=8 as=3.12 ps=7.6 w=1.2 l=0.6
X27 a_1381_36047# rx_n vdd_capture w_962_36261# sky130_fd_pr__pfet_01v8_hvt ad=0.05775 pd=0.695 as=0.1092 ps=1.36 w=0.42 l=0.15
X28 a_1634_36159# a_1466_36413# vss vss sky130_fd_pr__nfet_01v8 ad=0.0989 pd=0.995 as=0.12095 ps=1.085 w=0.64 l=0.15
X29 vss a_2059_36315# a_2017_36047# vss sky130_fd_pr__nfet_01v8 ad=0.1092 pd=1.36 as=0.066 ps=0.745 w=0.42 l=0.15
X30 iso_tail sense_n latch_sense_n vss sky130_fd_pr__nfet_01v8 ad=3.12 pd=7.6 as=3.36 ps=8 w=1.2 l=0.6
X31 rx_p out_p vdd_active vdd_active sky130_fd_pr__pfet_01v8 ad=0.1218 pd=1.42 as=0.1218 ps=1.42 w=0.42 l=0.15
X32 a_1193_36047# a_1027_36047# vdd_capture w_962_36261# sky130_fd_pr__pfet_01v8_hvt ad=0.1664 pd=1.8 as=0.0864 ps=0.91 w=0.64 l=0.15
X33 a_1592_36047# a_1193_36047# a_1466_36413# vss sky130_fd_pr__special_nfet_01v8 ad=0.0696 pd=0.765 as=0.0621 ps=0.705 w=0.36 l=0.15
X34 vdd_active out_n rx_n vdd_active sky130_fd_pr__pfet_01v8 ad=0.1218 pd=1.42 as=0.1218 ps=1.42 w=0.42 l=0.15
X35 vdd_capture capture_clk a_1027_36047# w_962_36261# sky130_fd_pr__pfet_01v8_hvt ad=0.0864 pd=0.91 as=0.1664 ps=1.8 w=0.64 l=0.15
X36 a_1193_36047# a_1027_36047# vss vss sky130_fd_pr__nfet_01v8 ad=0.1092 pd=1.36 as=0.0567 ps=0.69 w=0.42 l=0.15
X37 vss capture_clk a_1027_36047# vss sky130_fd_pr__nfet_01v8 ad=0.0567 pd=0.69 as=0.1092 ps=1.36 w=0.42 l=0.15
X38 vdd_active out_p out_n vdd_active sky130_fd_pr__pfet_01v8 ad=6.24 pd=10 as=6.72 ps=10.4 w=2.4 l=0.6
X39 latch_sense_p sense_p iso_tail vss sky130_fd_pr__nfet_01v8 ad=3.36 pd=8 as=3.12 ps=7.6 w=1.2 l=0.6
C0 a_2059_36315# rx_n 0.0026f
C1 captured_q vdd_capture 0.07024f
C2 a_2017_36047# a_1634_36159# 0
C3 sense_n iso_tail 0.03465f
C4 iso_tail sense_p 0.03465f
C5 vdd_capture a_1561_36413# 0.00405f
C6 reset out_n 0.31048f
C7 a_1466_36413# a_1193_36047# 0.07623f
C8 w_962_36261# a_1193_36047# 0.17847f
C9 a_1027_36047# a_1466_36413# 0.16041f
C10 w_962_36261# a_1027_36047# 0.25419f
C11 a_1466_36413# a_1381_36047# 0.02068f
C12 w_962_36261# a_1381_36047# 0.01589f
C13 out_p reset 0.31048f
C14 a_1891_36413# w_962_36261# 0.07294f
C15 latch_sense_n latch_sense_p 0.05388f
C16 rx_n a_1592_36047# 0.00137f
C17 vdd out_n 0.76206f
C18 a_1634_36159# a_1975_36413# 0.00131f
C19 tail rx_n 0.08768f
C20 vdd_capture rx_n 0.02947f
C21 a_2059_36315# vdd_capture 0.15521f
C22 a_1634_36159# a_1193_36047# 0.08347f
C23 w_962_36261# capture_clk 0.07825f
C24 tail latch_sense_n 0.0334f
C25 captured_q a_1466_36413# 0
C26 a_1891_36413# a_2017_36047# 0.00617f
C27 w_962_36261# captured_q 0.02005f
C28 a_1027_36047# a_1634_36159# 0.09081f
C29 a_1634_36159# a_1381_36047# 0
C30 eq_reset vdd_active 1.50445f
C31 out_p vdd 0.76206f
C32 a_1891_36413# a_1634_36159# 0.0205f
C33 latch_sense_n iso_tail 0.07366f
C34 a_1466_36413# a_1561_36413# 0.00772f
C35 captured_q a_2017_36047# 0
C36 tail latch_sense_p 0.0334f
C37 rx_n reset 0.08702f
C38 a_1193_36047# a_1975_36413# 0
C39 vdd_active out_n 3.49958f
C40 captured_q a_1634_36159# 0.00147f
C41 latch_sense_p iso_tail 0.07366f
C42 a_1891_36413# a_1975_36413# 0.00851f
C43 a_1027_36047# a_1193_36047# 0.56916f
C44 a_1193_36047# a_1381_36047# 0.06685f
C45 rx_n a_1466_36413# 0.0176f
C46 out_p vdd_active 3.44635f
C47 w_962_36261# rx_n 0.10097f
C48 a_1891_36413# a_1193_36047# 0.1112f
C49 a_2059_36315# w_962_36261# 0.15529f
C50 a_1027_36047# a_1381_36047# 0.04548f
C51 rx_n vdd 0.08702f
C52 a_1891_36413# a_1027_36047# 0.03079f
C53 rx_n eval 0
C54 capture_clk a_1193_36047# 0.00591f
C55 rx_p vdd_active 0.14036f
C56 rx_n a_2017_36047# 0
C57 captured_q a_1193_36047# 0
C58 a_2059_36315# a_2017_36047# 0
C59 capture_clk a_1027_36047# 0.15126f
C60 rx_n a_1634_36159# 0.01015f
C61 a_2059_36315# a_1634_36159# 0
C62 out_p out_n 2.57005f
C63 captured_q a_1027_36047# 0
C64 captured_q a_1381_36047# 0
C65 a_1891_36413# captured_q 0.00598f
C66 a_1027_36047# a_1561_36413# 0.0027f
C67 a_1466_36413# a_1592_36047# 0.00553f
C68 a_1561_36413# a_1381_36047# 0.00138f
C69 rx_p out_n 0
C70 rx_n vdd_active 0.25893f
C71 vdd_capture a_1466_36413# 0.11771f
C72 captured_q capture_clk 0
C73 w_962_36261# vdd_capture 0.20903f
C74 tail vdd 0.94872f
C75 latch_sense_n vdd_active 1.17466f
C76 tail eval 0.09536f
C77 eq_reset latch_sense_n 0.02611f
C78 rx_n a_1193_36047# 0.17985f
C79 out_p rx_p 0.05225f
C80 a_1634_36159# a_1592_36047# 0
C81 a_2059_36315# a_1193_36047# 0.01914f
C82 vdd_capture a_2017_36047# 0
C83 rx_n a_1027_36047# 0.07135f
C84 rx_n a_1381_36047# 0.09104f
C85 a_2059_36315# a_1027_36047# 0.02545f
C86 vdd_capture a_1634_36159# 0.06371f
C87 rx_n out_n 0.11016f
C88 latch_sense_p vdd_active 0.91317f
C89 a_1891_36413# rx_n 0.00434f
C90 a_1891_36413# a_2059_36315# 0.20625f
C91 latch_sense_n out_n 0.15098f
C92 eq_reset latch_sense_p 0.02611f
C93 reset vdd 4.03064f
C94 rx_n capture_clk 0.01314f
C95 tail vdd_active 1.43419f
C96 out_p rx_n 0.03556f
C97 captured_q rx_n 0.0027f
C98 a_2059_36315# captured_q 0.0652f
C99 w_962_36261# a_1466_36413# 0.07827f
C100 a_1193_36047# a_1592_36047# 0.00135f
C101 vdd_capture a_1975_36413# 0.00521f
C102 latch_sense_n sense_n 0.02861f
C103 rx_n a_1561_36413# 0
C104 vdd_capture a_1193_36047# 0.07896f
C105 tail out_n 0.18071f
C106 vdd_capture a_1027_36047# 0.23756f
C107 vdd_capture a_1381_36047# 0.03764f
C108 out_p latch_sense_p 0.15098f
C109 a_1891_36413# vdd_capture 0.0837f
C110 a_1466_36413# a_1634_36159# 0.16113f
C111 w_962_36261# a_1634_36159# 0.07963f
C112 latch_sense_p sense_p 0.02861f
C113 captured_q a_1592_36047# 0
C114 out_p tail 0.18071f
C115 vdd_capture capture_clk 0.07805f
C116 iso_tail vss 21.8637f
C117 sense_n vss 1.81302f
C118 sense_p vss 1.81302f
C119 eq_reset vss 0.42287f
C120 latch_sense_n vss 7.80027f
C121 latch_sense_p vss 8.19727f
C122 rx_p vss 0.78388f
C123 out_n vss 21.4637f
C124 out_p vss 21.5448f
C125 reset vss 5.45976f
C126 tail vss 42.1895f
C127 eval vss 1.02146f
C128 captured_q vss 0.35646f
C129 vdd_capture vss 0.85856f
C130 rx_n vss 8.72729f
C131 capture_clk vss 0.35666f
C132 vdd_active vss 0.12589p
C133 vdd vss 69.78f
C134 a_2017_36047# vss 0.0056f ; **FLOATING
C135 a_1592_36047# vss 0.00814f ; **FLOATING
C136 a_1975_36413# vss 0 ; **FLOATING
C137 a_1381_36047# vss 0.04915f ; **FLOATING
C138 a_1891_36413# vss 0.21511f ; **FLOATING
C139 a_2059_36315# vss 0.29022f ; **FLOATING
C140 a_1466_36413# vss 0.15975f ; **FLOATING
C141 a_1634_36159# vss 0.19161f ; **FLOATING
C142 a_1193_36047# vss 0.33181f ; **FLOATING
C143 a_1027_36047# vss 0.44405f ; **FLOATING
C144 w_962_36261# vss 1.50201f ; **FLOATING
.ends
