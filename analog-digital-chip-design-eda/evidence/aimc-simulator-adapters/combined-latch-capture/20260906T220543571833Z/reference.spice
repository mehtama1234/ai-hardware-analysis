* Intended circuit, written independently of extraction ordering.
* Sense pair drains drive the latch inputs; active load uses separate supply.
.subckt combined_latch_capture out_p out_n latch_sense_p
+ latch_sense_n tail reset vdd vss eval sense_p sense_n iso_tail vdd_active rx_p rx_n eq_reset capture_clk captured_q vdd_capture
Xiso_p latch_sense_p sense_p iso_tail vss sky130_fd_pr__nfet_01v8 w=1.2 l=0.6
Xiso_n latch_sense_n sense_n iso_tail vss sky130_fd_pr__nfet_01v8 w=1.2 l=0.6
Xsense_p out_p latch_sense_p tail vss sky130_fd_pr__nfet_01v8 w=1.2 l=0.6
Xsense_n out_n latch_sense_n tail vss sky130_fd_pr__nfet_01v8 w=1.2 l=0.6
Xfeedback_p out_p out_n tail vss sky130_fd_pr__nfet_01v8 w=1.2 l=0.6
Xfeedback_n out_n out_p tail vss sky130_fd_pr__nfet_01v8 w=1.2 l=0.6
Xtail tail eval vss vss sky130_fd_pr__nfet_01v8 w=6 l=0.6
Xload_p out_p out_n vdd_active vdd_active sky130_fd_pr__pfet_01v8 w=2.4 l=0.6
Xload_n out_n out_p vdd_active vdd_active sky130_fd_pr__pfet_01v8 w=2.4 l=0.6
Xreset_p out_p reset vdd vdd sky130_fd_pr__pfet_01v8 w=1.2 l=0.6
Xreset_n out_n reset vdd vdd sky130_fd_pr__pfet_01v8 w=1.2 l=0.6
XRXNp rx_p out_p vss vss sky130_fd_pr__nfet_01v8 w=0.42 l=0.15
XRXPp rx_p out_p vdd_active vdd_active sky130_fd_pr__pfet_01v8 w=0.42 l=0.15
XRXNn rx_n out_n vss vss sky130_fd_pr__nfet_01v8 w=0.42 l=0.15
XRXPn rx_n out_n vdd_active vdd_active sky130_fd_pr__pfet_01v8 w=0.42 l=0.15
Xequalizer latch_sense_p eq_reset latch_sense_n vdd_active sky130_fd_pr__pfet_01v8 w=1.2 l=0.6
XCAP capture_clk rx_n vss vss vdd_capture vdd_capture captured_q sky130_fd_sc_hd__dfxtp_1
.ends combined_latch_capture

* Copyright 2020 The SkyWater PDK Authors
* Licensed under the Apache License, Version 2.0 (the "License");
* you may not use this file except in compliance with the License.
* You may obtain a copy of the License at
* https://www.apache.org/licenses/LICENSE-2.0
* Unless required by applicable law or agreed to in writing, software
* distributed under the License is distributed on an "AS IS" BASIS,
* WITHOUT WARRANTIES OR CONDITIONS OF ANY KIND, either express or implied.
* See the License for the specific language governing permissions and
* limitations under the License.
* Unmodified cell selection from the installed library.
.subckt sky130_fd_sc_hd__dfxtp_1 CLK D VGND VNB VPB VPWR Q
X0 a_891_413# a_193_47# a_975_413# VPB sky130_fd_pr__pfet_01v8_hvt w=420000u l=150000u
X1 a_1059_315# a_891_413# VGND VNB sky130_fd_pr__nfet_01v8 w=650000u l=150000u
X2 a_466_413# a_27_47# a_561_413# VPB sky130_fd_pr__pfet_01v8_hvt w=420000u l=150000u
X3 a_634_159# a_27_47# a_891_413# VPB sky130_fd_pr__pfet_01v8_hvt w=420000u l=150000u
X4 a_381_47# a_193_47# a_466_413# VPB sky130_fd_pr__pfet_01v8_hvt w=420000u l=150000u
X5 VPWR D a_381_47# VPB sky130_fd_pr__pfet_01v8_hvt w=420000u l=150000u
X6 VPWR a_466_413# a_634_159# VPB sky130_fd_pr__pfet_01v8_hvt w=750000u l=150000u
X7 VGND a_466_413# a_634_159# VNB sky130_fd_pr__nfet_01v8 w=640000u l=150000u
X8 a_1017_47# a_1059_315# VGND VNB sky130_fd_pr__nfet_01v8 w=420000u l=150000u
X9 a_1059_315# a_891_413# VPWR VPB sky130_fd_pr__pfet_01v8_hvt w=1e+06u l=150000u
X10 a_561_413# a_634_159# VPWR VPB sky130_fd_pr__pfet_01v8_hvt w=420000u l=150000u
X11 VPWR a_1059_315# Q VPB sky130_fd_pr__pfet_01v8_hvt w=1e+06u l=150000u
X12 a_891_413# a_27_47# a_1017_47# VNB sky130_fd_pr__special_nfet_01v8 w=360000u l=150000u
X13 a_634_159# a_193_47# a_891_413# VNB sky130_fd_pr__special_nfet_01v8 w=360000u l=150000u
X14 a_592_47# a_634_159# VGND VNB sky130_fd_pr__nfet_01v8 w=420000u l=150000u
X15 a_466_413# a_193_47# a_592_47# VNB sky130_fd_pr__special_nfet_01v8 w=360000u l=150000u
X16 VGND a_27_47# a_193_47# VNB sky130_fd_pr__nfet_01v8 w=420000u l=150000u
X17 a_381_47# a_27_47# a_466_413# VNB sky130_fd_pr__special_nfet_01v8 w=360000u l=150000u
X18 a_27_47# CLK VGND VNB sky130_fd_pr__nfet_01v8 w=420000u l=150000u
X19 a_27_47# CLK VPWR VPB sky130_fd_pr__pfet_01v8_hvt w=640000u l=150000u
X20 VPWR a_27_47# a_193_47# VPB sky130_fd_pr__pfet_01v8_hvt w=640000u l=150000u
X21 VGND D a_381_47# VNB sky130_fd_pr__nfet_01v8 w=420000u l=150000u
X22 a_975_413# a_1059_315# VPWR VPB sky130_fd_pr__pfet_01v8_hvt w=420000u l=150000u
X23 VGND a_1059_315# Q VNB sky130_fd_pr__nfet_01v8 w=650000u l=150000u
.ends
