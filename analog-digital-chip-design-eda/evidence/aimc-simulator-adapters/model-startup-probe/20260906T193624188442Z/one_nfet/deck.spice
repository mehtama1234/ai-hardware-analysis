* Model startup isolation
.lib "/home/mehtama1/eda-tools/pdks/sky130A/libs.tech/ngspice/sky130.lib.spice" tt
V1 a 0 1
VG g 0 0.9
X1 a g 0 0 sky130_fd_pr__nfet_01v8 w=1.2 l=0.6
.op
.control
echo CONTROL_ENTERED
op
print v(a)
quit
.endc
.end
