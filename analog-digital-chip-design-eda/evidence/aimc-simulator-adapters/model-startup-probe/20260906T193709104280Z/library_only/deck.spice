* Model startup isolation
.lib "/home/mehtama1/eda-tools/pdks/sky130A/libs.tech/ngspice/sky130.lib.spice" tt
V1 a 0 1
R1 a 0 1k
.op
.control
echo CONTROL_ENTERED
op
print v(a)
quit
.endc
.end
