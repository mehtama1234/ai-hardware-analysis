* Model startup isolation
V1 a 0 1
R1 a 0 1k
.op
.control
echo CONTROL_ENTERED
op
print v(a)
quit
.endc
.end
