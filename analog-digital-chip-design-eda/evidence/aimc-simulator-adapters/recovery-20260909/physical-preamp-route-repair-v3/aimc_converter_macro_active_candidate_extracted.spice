* NGSPICE file created from aimc_converter_macro_active_candidate_flat.ext - technology: sky130A

.subckt aimc_converter_macro_active_candidate_flat vss vdd row_drive sar_comparator_input
+ decision_p decision_n reset eval vss_escape latch_sense_p_ext latch_sense_n_ext
+ iso_tail_ext tail_ext vdd_ext preamp_iso_tail_ext
X0 preamp_iso_tail_ext sar_comparator_input latch_sense_n_ext vss_escape sky130_fd_pr__nfet_01v8 ad=3.12 pd=7.6 as=3.36 ps=8 w=1.2 l=0.6
X1 vdd_ext decision_p decision_n vdd_ext sky130_fd_pr__pfet_01v8 ad=3.12 pd=7.6 as=3.36 ps=8 w=1.2 l=0.6
X2 tail_ext eval vss_escape vss_escape sky130_fd_pr__nfet_01v8 ad=16.2 pd=17.4 as=16.2 ps=17.4 w=6 l=0.6
X3 latch_sense_p_ext row_drive preamp_iso_tail_ext vss_escape sky130_fd_pr__nfet_01v8 ad=3.36 pd=8 as=3.12 ps=7.6 w=1.2 l=0.6
X4 decision_p latch_sense_p_ext tail_ext vss_escape sky130_fd_pr__nfet_01v8 ad=3.36 pd=8 as=3.12 ps=7.6 w=1.2 l=0.6
X5 vdd_ext reset decision_n vdd_ext sky130_fd_pr__pfet_01v8 ad=3.12 pd=7.6 as=3.36 ps=8 w=1.2 l=0.6
X6 tail_ext latch_sense_n_ext decision_n vss_escape sky130_fd_pr__nfet_01v8 ad=3.12 pd=7.6 as=3.36 ps=8 w=1.2 l=0.6
X7 decision_p decision_n vdd_ext vdd_ext sky130_fd_pr__pfet_01v8 ad=3.36 pd=8 as=3.12 ps=7.6 w=1.2 l=0.6
X8 tail_ext decision_p decision_n vss_escape sky130_fd_pr__nfet_01v8 ad=3.12 pd=7.6 as=3.36 ps=8 w=1.2 l=0.6
X9 latch_sense_p_ext row_drive iso_tail_ext vss_escape sky130_fd_pr__nfet_01v8 ad=3.36 pd=8 as=3.12 ps=7.6 w=1.2 l=0.6
X10 iso_tail_ext sar_comparator_input latch_sense_n_ext vss_escape sky130_fd_pr__nfet_01v8 ad=3.12 pd=7.6 as=3.36 ps=8 w=1.2 l=0.6
X11 decision_p reset vdd_ext vdd_ext sky130_fd_pr__pfet_01v8 ad=3.36 pd=8 as=3.12 ps=7.6 w=1.2 l=0.6
X12 decision_p decision_n tail_ext vss_escape sky130_fd_pr__nfet_01v8 ad=3.36 pd=8 as=3.12 ps=7.6 w=1.2 l=0.6
C0 decision_p reset 0.376f
C1 decision_n reset 0.31048f
C2 preamp_iso_tail_ext row_drive 0.1517f
C3 vss shared_converter_mux_0.mux_bus 0.03132f
C4 vss latch_sense_n_ext 0.23329f
C5 eval vdd_ext 0
C6 latch_sense_n_ext sar_comparator_input 0.32316f
C7 reset vdd_ext 4.48789f
C8 vdd_ext row_drive 2.23393f
C9 latch_sense_n_ext latch_sense_p_ext 3.0474f
C10 vdd_ext shared_converter_mux_0.vss 0
C11 vdd_ext sar_readout_12b_0.vdd 1.39936f
C12 vss latch_sense_p_ext 0.23329f
C13 latch_sense_p_ext sar_comparator_input 0.60212f
C14 row_drive shared_converter_mux_0.vss 0.00246f
C15 row_dac_10b_0.vdd row_drive 1.11462f
C16 row_drive sar_readout_12b_0.vdd 0.57218f
C17 tail_ext latch_sense_n_ext 0.0334f
C18 shared_converter_mux_0.vdd shared_converter_mux_0.mux_bus 1.55306f
C19 vdd_ext iso_tail_ext 0.3078f
C20 shared_converter_mux_0.vdd vss 0.2816f
C21 tail_ext latch_sense_p_ext 0.0334f
C22 row_drive iso_tail_ext 1.97962f
C23 sar_readout_12b_0.vdd iso_tail_ext 0.27521f
C24 decision_n latch_sense_n_ext 0.18428f
C25 vdd_ext sar_readout_12b_0.vss 0.93663f
C26 preamp_iso_tail_ext latch_sense_n_ext 0.20434f
C27 row_dac_10b_0.vss row_drive 1.08123f
C28 sar_readout_12b_0.vss row_drive 0.29422f
C29 vdd_ext shared_converter_mux_0.mux_bus 0.00217f
C30 preamp_iso_tail_ext sar_comparator_input 0.16238f
C31 vdd_ext latch_sense_n_ext 0.17029f
C32 row_dac_10b_0.vdd row_dac_10b_0.vss 0.78467f
C33 decision_p latch_sense_p_ext 0.18428f
C34 sar_readout_12b_0.vss sar_readout_12b_0.vdd 0.49712f
C35 vss vdd_ext 0.19458f
C36 preamp_iso_tail_ext latch_sense_p_ext 0.15769f
C37 row_drive shared_converter_mux_0.mux_bus 0.06281f
C38 vdd_ext sar_comparator_input 0.06859f
C39 row_drive latch_sense_n_ext 0.22403f
C40 shared_converter_mux_0.mux_bus shared_converter_mux_0.vss 1.56188f
C41 vdd row_drive 0.1964f
C42 decision_p tail_ext 0.48065f
C43 vss row_drive 0.22445f
C44 vdd_ext latch_sense_p_ext 0.16934f
C45 decision_n tail_ext 0.48065f
C46 row_drive sar_comparator_input 5.2857f
C47 sar_readout_12b_0.vss iso_tail_ext 0.60045f
C48 row_drive latch_sense_p_ext 1.32116f
C49 vdd_ext tail_ext 1.9856f
C50 latch_sense_n_ext iso_tail_ext 0.21375f
C51 eval tail_ext 0.36751f
C52 shared_converter_mux_0.vdd vdd_ext 0
C53 reset tail_ext 0.17577f
C54 decision_n decision_p 2.54301f
C55 sar_comparator_input iso_tail_ext 0.16721f
C56 shared_converter_mux_0.vdd row_drive 0.00246f
C57 latch_sense_p_ext iso_tail_ext 0.94274f
C58 decision_p vdd_ext 3.8282f
C59 decision_n vdd_ext 3.9382f
C60 vss vss_escape 36.2394f
C61 vdd vss_escape 36.7f
C62 preamp_iso_tail_ext vss_escape 38.41623f
C63 iso_tail_ext vss_escape 22.0483f
C64 decision_p vss_escape 14.57727f
C65 tail_ext vss_escape 0.13729p
C66 vdd_ext vss_escape 0.24475p
C67 sar_readout_12b_0.vss vss_escape 1.33686f ; **FLOATING
C68 row_dac_10b_0.vss vss_escape 1.40333f ; **FLOATING
C69 row_dac_10b_0.vdd vss_escape 1.33457f ; **FLOATING
C70 sar_readout_12b_0.vdd vss_escape 1.77614f ; **FLOATING
C71 shared_converter_mux_0.vss vss_escape 1.39454f ; **FLOATING
C72 shared_converter_mux_0.mux_bus vss_escape 2.86922f ; **FLOATING
C73 shared_converter_mux_0.vdd vss_escape 0.95985f ; **FLOATING
.ends
