* Intended active macro: existing independent latch circuit and added differential pair.
.include latch_reference.spice
.subckt aimc_converter_macro_active_candidate_flat vss vdd row_drive sar_comparator_input
+ decision_p decision_n reset eval vss_escape latch_sense_p_ext latch_sense_n_ext
+ iso_tail_ext tail_ext vdd_ext preamp_iso_tail_ext
Xcore decision_p decision_n latch_sense_p_ext latch_sense_n_ext tail_ext reset
+ vdd_ext vss_escape eval row_drive sar_comparator_input iso_tail_ext vdd_ext
+ sky130_isolated_frontend_active_load_latch_v2
Xpreamp_p latch_sense_p_ext row_drive preamp_iso_tail_ext vss_escape sky130_fd_pr__nfet_01v8 w=2.4 l=0.6
Xpreamp_n latch_sense_n_ext sar_comparator_input preamp_iso_tail_ext vss_escape sky130_fd_pr__nfet_01v8 w=1.2 l=0.6
.ends aimc_converter_macro_active_candidate_flat
