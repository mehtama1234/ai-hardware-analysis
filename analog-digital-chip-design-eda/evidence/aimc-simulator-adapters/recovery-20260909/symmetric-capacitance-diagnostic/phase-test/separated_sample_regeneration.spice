* SCHEMATIC EXPERIMENT: modified topology, inherited parasitics are provisional
* SYNTHETIC SCHEMATIC DIAGNOSTIC: half original and half side-mirrored parasitic capacitance; not extracted layout
* NGSPICE file created from aimc_converter_macro_active_candidate_flat.ext - technology: sky130A

.subckt aimc_converter_macro_active_candidate_flat vss vdd row_drive sar_comparator_input
+ decision_p decision_n reset eval vss_escape latch_sense_p_ext latch_sense_n_ext
+ iso_tail_ext tail_ext vdd_ext preamp_iso_tail_ext sample_clock regen_bar
X0 preamp_iso_tail_ext sar_comparator_input latch_sense_n_ext vss_escape sky130_fd_pr__nfet_01v8 ad=3.12 pd=7.6 as=3.36 ps=8 w=1.2 l=0.6
X1 regen_vdd decision_p decision_n vdd_ext sky130_fd_pr__pfet_01v8 ad=3.12 pd=7.6 as=3.36 ps=8 w=1.2 l=0.6
X2 tail_ext eval vss_escape vss_escape sky130_fd_pr__nfet_01v8 ad=16.2 pd=17.4 as=16.2 ps=17.4 w=6 l=0.6
X3 latch_sense_p_ext row_drive preamp_iso_tail_ext vss_escape sky130_fd_pr__nfet_01v8 ad=3.36 pd=8 as=3.12 ps=7.6 w=1.2 l=0.6
X4 decision_p latch_sense_p_ext sample_tail vss_escape sky130_fd_pr__nfet_01v8 ad=3.36 pd=8 as=3.12 ps=7.6 w=1.2 l=0.6
X5 vdd_ext reset decision_n vdd_ext sky130_fd_pr__pfet_01v8 ad=3.12 pd=7.6 as=3.36 ps=8 w=1.2 l=0.6
X6 sample_tail latch_sense_n_ext decision_n vss_escape sky130_fd_pr__nfet_01v8 ad=3.12 pd=7.6 as=3.36 ps=8 w=1.2 l=0.6
X7 decision_p decision_n regen_vdd vdd_ext sky130_fd_pr__pfet_01v8 ad=3.36 pd=8 as=3.12 ps=7.6 w=1.2 l=0.6
X8 tail_ext decision_p decision_n vss_escape sky130_fd_pr__nfet_01v8 ad=3.12 pd=7.6 as=3.36 ps=8 w=1.2 l=0.6
X9 latch_sense_p_ext row_drive iso_tail_ext vss_escape sky130_fd_pr__nfet_01v8 ad=3.36 pd=8 as=3.12 ps=7.6 w=1.2 l=0.6
X10 iso_tail_ext sar_comparator_input latch_sense_n_ext vss_escape sky130_fd_pr__nfet_01v8 ad=3.12 pd=7.6 as=3.36 ps=8 w=1.2 l=0.6
X11 decision_p reset vdd_ext vdd_ext sky130_fd_pr__pfet_01v8 ad=3.36 pd=8 as=3.12 ps=7.6 w=1.2 l=0.6
X12 decision_p decision_n tail_ext vss_escape sky130_fd_pr__nfet_01v8 ad=3.36 pd=8 as=3.12 ps=7.6 w=1.2 l=0.6
C0original sar_readout_12b_0.vdd vdd_ext 0.701575f
C0mirror sar_readout_12b_0.vdd vdd_ext 0.701575f
C1original sar_readout_12b_0.vss iso_tail_ext 0.240815f
C1mirror sar_readout_12b_0.vss iso_tail_ext 0.240815f
C2original vdd_ext shared_converter_mux_0.mux_bus 0.001085f
C2mirror vdd_ext shared_converter_mux_0.mux_bus 0.001085f
C3original vdd_ext decision_n 1.898815f
C3mirror vdd_ext decision_p 1.898815f
C4original latch_sense_n_ext preamp_iso_tail_ext 0.122775f
C4mirror latch_sense_p_ext preamp_iso_tail_ext 0.122775f
C5original row_drive sar_comparator_input 0.743855f
C5mirror sar_comparator_input row_drive 0.743855f
C6original vdd_ext latch_sense_n_ext 0.15031f
C6mirror vdd_ext latch_sense_p_ext 0.15031f
C7original sar_comparator_input latch_sense_p_ext 0.79232f
C7mirror row_drive latch_sense_n_ext 0.79232f
C8original shared_converter_mux_0.vss shared_converter_mux_0.mux_bus 0.78094f
C8mirror shared_converter_mux_0.vss shared_converter_mux_0.mux_bus 0.78094f
C9original vdd_ext eval 0
C9mirror vdd_ext eval 0
C10original row_drive vdd 0.0982f
C10mirror sar_comparator_input vdd 0.0982f
C11original shared_converter_mux_0.vdd vss 0.1408f
C11mirror shared_converter_mux_0.vdd vss 0.1408f
C12original vdd_ext reset 2.218495f
C12mirror vdd_ext reset 2.218495f
C13original row_dac_10b_0.vdd row_drive 0.56345f
C13mirror row_dac_10b_0.vdd sar_comparator_input 0.56345f
C14original decision_p latch_sense_p_ext 0.093825f
C14mirror decision_n latch_sense_n_ext 0.093825f
C15original tail_ext latch_sense_p_ext 0.01818f
C15mirror tail_ext latch_sense_n_ext 0.01818f
C16original preamp_iso_tail_ext sar_comparator_input 0.082565f
C16mirror preamp_iso_tail_ext row_drive 0.082565f
C17original vdd_ext sar_comparator_input 0.036115f
C17mirror vdd_ext row_drive 0.036115f
C18original sar_readout_12b_0.vss row_drive 0.17137f
C18mirror sar_readout_12b_0.vss sar_comparator_input 0.17137f
C19original row_drive shared_converter_mux_0.vdd 0.00123f
C19mirror sar_comparator_input shared_converter_mux_0.vdd 0.00123f
C20original row_drive iso_tail_ext 0.73356f
C20mirror sar_comparator_input iso_tail_ext 0.73356f
C21original row_dac_10b_0.vdd row_dac_10b_0.vss 0.392335f
C21mirror row_dac_10b_0.vdd row_dac_10b_0.vss 0.392335f
C22original iso_tail_ext latch_sense_p_ext 0.72751f
C22mirror iso_tail_ext latch_sense_n_ext 0.72751f
C23original vdd_ext decision_p 1.852635f
C23mirror vdd_ext decision_n 1.852635f
C24original vdd_ext tail_ext 0.99393f
C24mirror vdd_ext tail_ext 0.99393f
C25original row_drive vss 0.112225f
C25mirror sar_comparator_input vss 0.112225f
C26original vss latch_sense_p_ext 0.116775f
C26mirror vss latch_sense_n_ext 0.116775f
C27original vdd_ext sar_readout_12b_0.vss 0.47858f
C27mirror vdd_ext sar_readout_12b_0.vss 0.47858f
C28original vdd_ext shared_converter_mux_0.vdd 0
C28mirror vdd_ext shared_converter_mux_0.vdd 0
C29original vdd_ext iso_tail_ext 0.164695f
C29mirror vdd_ext iso_tail_ext 0.164695f
C30original row_drive latch_sense_p_ext 2.5819f
C30mirror sar_comparator_input latch_sense_n_ext 2.5819f
C31original latch_sense_n_ext decision_n 0.093825f
C31mirror latch_sense_p_ext decision_p 0.093825f
C32original vdd_ext vss 0.09729f
C32mirror vdd_ext vss 0.09729f
C33original decision_n reset 0.156785f
C33mirror decision_p reset 0.156785f
C34original row_dac_10b_0.vss row_drive 0.542875f
C34mirror row_dac_10b_0.vss sar_comparator_input 0.542875f
C35original row_drive preamp_iso_tail_ext 0.0661f
C35mirror sar_comparator_input preamp_iso_tail_ext 0.0661f
C36original vdd_ext row_drive 0.89138f
C36mirror vdd_ext sar_comparator_input 0.89138f
C37original preamp_iso_tail_ext latch_sense_p_ext 0.07714f
C37mirror preamp_iso_tail_ext latch_sense_n_ext 0.07714f
C38original vdd_ext latch_sense_p_ext 0.149315f
C38mirror vdd_ext latch_sense_n_ext 0.149315f
C39original latch_sense_n_ext sar_comparator_input 0.178535f
C39mirror latch_sense_p_ext row_drive 0.178535f
C40original row_drive shared_converter_mux_0.vss 0.00123f
C40mirror sar_comparator_input shared_converter_mux_0.vss 0.00123f
C41original decision_p decision_n 1.27978f
C41mirror decision_n decision_p 1.27978f
C42original tail_ext decision_n 0.24004f
C42mirror tail_ext decision_p 0.24004f
C43original sar_readout_12b_0.vdd sar_readout_12b_0.vss 0.255225f
C43mirror sar_readout_12b_0.vdd sar_readout_12b_0.vss 0.255225f
C44original latch_sense_n_ext tail_ext 0.01818f
C44mirror latch_sense_p_ext tail_ext 0.01818f
C45original sar_readout_12b_0.vdd iso_tail_ext 0.142625f
C45mirror sar_readout_12b_0.vdd iso_tail_ext 0.142625f
C46original tail_ext eval 0.189675f
C46mirror tail_ext eval 0.189675f
C47original decision_p reset 0.189005f
C47mirror decision_n reset 0.189005f
C48original shared_converter_mux_0.vdd shared_converter_mux_0.mux_bus 0.77653f
C48mirror shared_converter_mux_0.vdd shared_converter_mux_0.mux_bus 0.77653f
C49original tail_ext reset 0.08945f
C49mirror tail_ext reset 0.08945f
C50original vdd_ext shared_converter_mux_0.vss 0
C50mirror vdd_ext shared_converter_mux_0.vss 0
C51original latch_sense_n_ext iso_tail_ext 0.12376f
C51mirror latch_sense_p_ext iso_tail_ext 0.12376f
C52original vss shared_converter_mux_0.mux_bus 0.01566f
C52mirror vss shared_converter_mux_0.mux_bus 0.01566f
C53original latch_sense_n_ext vss 0.116775f
C53mirror latch_sense_p_ext vss 0.116775f
C54original tail_ext decision_p 0.240085f
C54mirror tail_ext decision_n 0.240085f
C55original sar_readout_12b_0.vdd row_drive 0.217975f
C55mirror sar_readout_12b_0.vdd sar_comparator_input 0.217975f
C56original sar_comparator_input iso_tail_ext 0.099485f
C56mirror row_drive iso_tail_ext 0.099485f
C57original sar_readout_12b_0.vdd latch_sense_p_ext 0.00831f
C57mirror sar_readout_12b_0.vdd latch_sense_n_ext 0.00831f
C58original row_drive shared_converter_mux_0.mux_bus 0.031405f
C58mirror sar_comparator_input shared_converter_mux_0.mux_bus 0.031405f
C59original row_drive latch_sense_n_ext 0.017025f
C59mirror sar_comparator_input latch_sense_p_ext 0.017025f
C60original latch_sense_n_ext latch_sense_p_ext 1.1494f
C60mirror latch_sense_p_ext latch_sense_n_ext 1.1494f
C61original vss vss_escape 18.1189f
C61mirror vss vss_escape 18.1189f
C62original vdd vss_escape 18.35f
C62mirror vdd vss_escape 18.35f
C63original preamp_iso_tail_ext vss_escape 19.058325f
C63mirror preamp_iso_tail_ext vss_escape 19.058325f
C64original iso_tail_ext vss_escape 12.6086f
C64mirror iso_tail_ext vss_escape 12.6086f
C65original decision_p vss_escape 7.14386f
C65mirror decision_n vss_escape 7.14386f
C66original tail_ext vss_escape 0.06801p
C66mirror tail_ext vss_escape 0.06801p
C67original vdd_ext vss_escape 0.123175p
C67mirror vdd_ext vss_escape 0.123175p
C68original sar_readout_12b_0.vss vss_escape 0.66929f
C68mirror sar_readout_12b_0.vss vss_escape 0.66929f
C69original row_dac_10b_0.vss vss_escape 0.701665f
C69mirror row_dac_10b_0.vss vss_escape 0.701665f
C70original row_dac_10b_0.vdd vss_escape 0.666425f
C70mirror row_dac_10b_0.vdd vss_escape 0.666425f
C71original sar_readout_12b_0.vdd vss_escape 0.88732f
C71mirror sar_readout_12b_0.vdd vss_escape 0.88732f
C72original shared_converter_mux_0.vss vss_escape 0.69727f
C72mirror shared_converter_mux_0.vss vss_escape 0.69727f
C73original shared_converter_mux_0.mux_bus vss_escape 1.43461f
C73mirror shared_converter_mux_0.mux_bus vss_escape 1.43461f
C74original shared_converter_mux_0.vdd vss_escape 0.479925f
C74mirror shared_converter_mux_0.vdd vss_escape 0.479925f
Xsample_tail sample_tail sample_clock vss_escape vss_escape sky130_fd_pr__nfet_01v8 w=6 l=0.6
Xregen_header regen_vdd regen_bar vdd_ext vdd_ext sky130_fd_pr__pfet_01v8 w=6 l=0.6
.ends
