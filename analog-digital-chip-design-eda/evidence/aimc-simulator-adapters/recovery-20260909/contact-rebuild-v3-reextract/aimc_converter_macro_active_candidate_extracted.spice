* NGSPICE file created from aimc_converter_macro_active_candidate_flat.ext - technology: sky130A

.subckt aimc_converter_macro_active_candidate_flat vss vdd row_drive sar_comparator_input
+ decision_p decision_n reset eval vss_escape latch_sense_p_ext latch_sense_n_ext
+ iso_tail_ext tail_ext vdd_ext preamp_iso_tail_ext
X0 preamp_iso_tail_ext sar_comparator_input latch_sense_n_ext vss_escape sky130_fd_pr__nfet_01v8 ad=3.12 pd=7.6 as=3.36 ps=8 w=1.2 l=0.6
X1 vdd_ext decision_p decision_n vdd_ext sky130_fd_pr__pfet_01v8 ad=3.12 pd=7.6 as=3.36 ps=8 w=1.2 l=0.6
X2 tail_ext eval vss_escape vss_escape sky130_fd_pr__nfet_01v8 ad=16.2 pd=17.4 as=16.2 ps=17.4 w=6 l=0.6
X3 latch_sense_p_ext row_drive preamp_iso_tail_ext vss_escape sky130_fd_pr__nfet_01v8 ad=3.36 pd=8 as=3.12 ps=7.6 w=1.2 l=0.6
X4 decision_p latch_sense_p_ext tail_ext vss_escape sky130_fd_pr__nfet_01v8 ad=3.36 pd=8 as=3.12 ps=7.6 w=1.2 l=0.6
X5 vdd_ext reset decision_n vdd_ext sky130_fd_pr__pfet_01v8 ad=3.12 pd=7.6 as=3.36 ps=8 w=1.2 l=0.6
X6 tail_ext latch_sense_n_ext decision_n vss_escape sky130_fd_pr__nfet_01v8 ad=3.12 pd=7.6 as=3.36 ps=8 w=1.2 l=0.6
X7 decision_p decision_n vdd_ext vdd_ext sky130_fd_pr__pfet_01v8 ad=3.36 pd=8 as=3.12 ps=7.6 w=1.2 l=0.6
X8 tail_ext decision_p decision_n vss_escape sky130_fd_pr__nfet_01v8 ad=3.12 pd=7.6 as=3.36 ps=8 w=1.2 l=0.6
X9 latch_sense_p_ext row_drive iso_tail_ext vss_escape sky130_fd_pr__nfet_01v8 ad=3.36 pd=8 as=3.12 ps=7.6 w=1.2 l=0.6
X10 iso_tail_ext sar_comparator_input latch_sense_n_ext vss_escape sky130_fd_pr__nfet_01v8 ad=3.12 pd=7.6 as=3.36 ps=8 w=1.2 l=0.6
X11 decision_p reset vdd_ext vdd_ext sky130_fd_pr__pfet_01v8 ad=3.36 pd=8 as=3.12 ps=7.6 w=1.2 l=0.6
X12 decision_p decision_n tail_ext vss_escape sky130_fd_pr__nfet_01v8 ad=3.36 pd=8 as=3.12 ps=7.6 w=1.2 l=0.6
C0 latch_sense_n_ext vdd_ext 0.30062f
C1 latch_sense_n_ext tail_ext 0.03636f
C2 vss shared_converter_mux_0.mux_bus 0.03132f
C3 latch_sense_p_ext vss 0.23355f
C4 vss row_drive 0.22445f
C5 shared_converter_mux_0.vdd vdd_ext 0
C6 row_drive shared_converter_mux_0.mux_bus 0.06281f
C7 shared_converter_mux_0.vss shared_converter_mux_0.mux_bus 1.56188f
C8 decision_n decision_p 2.55956f
C9 vdd_ext decision_n 3.79763f
C10 sar_readout_12b_0.vss row_drive 0.34274f
C11 decision_n tail_ext 0.48008f
C12 sar_readout_12b_0.vss iso_tail_ext 0.48163f
C13 latch_sense_p_ext row_drive 5.1638f
C14 iso_tail_ext latch_sense_p_ext 1.45502f
C15 shared_converter_mux_0.vss row_drive 0.00246f
C16 iso_tail_ext row_drive 1.46712f
C17 latch_sense_p_ext preamp_iso_tail_ext 0.15428f
C18 preamp_iso_tail_ext row_drive 0.1322f
C19 row_dac_10b_0.vdd row_dac_10b_0.vss 0.78467f
C20 vss vdd_ext 0.19458f
C21 vdd_ext shared_converter_mux_0.mux_bus 0.00217f
C22 reset decision_n 0.31357f
C23 latch_sense_p_ext sar_comparator_input 1.58464f
C24 row_drive sar_comparator_input 1.48771f
C25 latch_sense_n_ext decision_n 0.18765f
C26 latch_sense_p_ext decision_p 0.18765f
C27 sar_readout_12b_0.vss vdd_ext 0.95716f
C28 iso_tail_ext sar_comparator_input 0.19897f
C29 preamp_iso_tail_ext sar_comparator_input 0.16513f
C30 latch_sense_p_ext vdd_ext 0.29863f
C31 row_drive vdd_ext 1.78276f
C32 vdd row_drive 0.1964f
C33 sar_readout_12b_0.vdd sar_readout_12b_0.vss 0.51045f
C34 latch_sense_p_ext tail_ext 0.03636f
C35 shared_converter_mux_0.vss vdd_ext 0
C36 iso_tail_ext vdd_ext 0.32939f
C37 sar_readout_12b_0.vdd latch_sense_p_ext 0.01662f
C38 sar_readout_12b_0.vdd row_drive 0.43595f
C39 eval vdd_ext 0
C40 sar_readout_12b_0.vdd iso_tail_ext 0.28525f
C41 latch_sense_n_ext vss 0.23355f
C42 eval tail_ext 0.37935f
C43 row_dac_10b_0.vss row_drive 1.08575f
C44 sar_comparator_input vdd_ext 0.07223f
C45 vdd_ext decision_p 3.70527f
C46 latch_sense_n_ext latch_sense_p_ext 2.2988f
C47 latch_sense_n_ext row_drive 0.03405f
C48 decision_p tail_ext 0.48017f
C49 iso_tail_ext latch_sense_n_ext 0.24752f
C50 vdd_ext tail_ext 1.98786f
C51 shared_converter_mux_0.vdd vss 0.2816f
C52 latch_sense_n_ext preamp_iso_tail_ext 0.24555f
C53 shared_converter_mux_0.vdd shared_converter_mux_0.mux_bus 1.55306f
C54 sar_readout_12b_0.vdd vdd_ext 1.40315f
C55 reset decision_p 0.37801f
C56 latch_sense_n_ext sar_comparator_input 0.35707f
C57 vdd_ext reset 4.43699f
C58 shared_converter_mux_0.vdd row_drive 0.00246f
C59 reset tail_ext 0.1789f
C60 row_dac_10b_0.vdd row_drive 1.1269f
C61 vss vss_escape 36.2378f
C62 vdd vss_escape 36.7f
C63 preamp_iso_tail_ext vss_escape 38.11665f
C64 iso_tail_ext vss_escape 25.2172f
C65 decision_p vss_escape 14.28772f
C66 tail_ext vss_escape 0.13602p
C67 vdd_ext vss_escape 0.24635p
C68 sar_readout_12b_0.vss vss_escape 1.33858f ; **FLOATING
C69 row_dac_10b_0.vss vss_escape 1.40333f ; **FLOATING
C70 row_dac_10b_0.vdd vss_escape 1.33285f ; **FLOATING
C71 sar_readout_12b_0.vdd vss_escape 1.77464f ; **FLOATING
C72 shared_converter_mux_0.vss vss_escape 1.39454f ; **FLOATING
C73 shared_converter_mux_0.mux_bus vss_escape 2.86922f ; **FLOATING
C74 shared_converter_mux_0.vdd vss_escape 0.95985f ; **FLOATING
.ends
