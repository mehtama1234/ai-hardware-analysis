* NGSPICE file created from aimc_converter_macro_active_candidate_flat.ext - technology: sky130A

.subckt aimc_converter_macro_active_candidate_flat vss vdd row_drive sar_comparator_input
+ decision_p decision_n reset eval vss_escape iso_tail_ext tail_ext vdd_ext preamp_iso_tail_ext
X0 preamp_iso_tail_ext sar_comparator_input vdd_ext vss_escape sky130_fd_pr__nfet_01v8 ad=3.12 pd=7.6 as=3.36 ps=8 w=1.2 l=0.6
X1 vdd_ext decision_p decision_n vdd_ext sky130_fd_pr__pfet_01v8 ad=3.12 pd=7.6 as=3.36 ps=8 w=1.2 l=0.6
X2 tail_ext eval vss_escape vss_escape sky130_fd_pr__nfet_01v8 ad=16.2 pd=17.4 as=16.2 ps=17.4 w=6 l=0.6
X3 vdd_ext row_drive preamp_iso_tail_ext vss_escape sky130_fd_pr__nfet_01v8 ad=3.36 pd=8 as=3.12 ps=7.6 w=1.2 l=0.6
X4 decision_p vdd_ext tail_ext vss_escape sky130_fd_pr__nfet_01v8 ad=3.36 pd=8 as=3.12 ps=7.6 w=1.2 l=0.6
X5 vdd_ext reset decision_n vdd_ext sky130_fd_pr__pfet_01v8 ad=3.12 pd=7.6 as=3.36 ps=8 w=1.2 l=0.6
X6 tail_ext vdd_ext decision_n vss_escape sky130_fd_pr__nfet_01v8 ad=3.12 pd=7.6 as=3.36 ps=8 w=1.2 l=0.6
X7 decision_p decision_n vdd_ext vdd_ext sky130_fd_pr__pfet_01v8 ad=3.36 pd=8 as=3.12 ps=7.6 w=1.2 l=0.6
X8 tail_ext decision_p decision_n vss_escape sky130_fd_pr__nfet_01v8 ad=3.12 pd=7.6 as=3.36 ps=8 w=1.2 l=0.6
X9 vdd_ext row_drive iso_tail_ext vss_escape sky130_fd_pr__nfet_01v8 ad=3.36 pd=8 as=3.12 ps=7.6 w=1.2 l=0.6
X10 iso_tail_ext sar_comparator_input vdd_ext vss_escape sky130_fd_pr__nfet_01v8 ad=3.12 pd=7.6 as=3.36 ps=8 w=1.2 l=0.6
X11 decision_p reset vdd_ext vdd_ext sky130_fd_pr__pfet_01v8 ad=3.36 pd=8 as=3.12 ps=7.6 w=1.2 l=0.6
X12 decision_p decision_n tail_ext vss_escape sky130_fd_pr__nfet_01v8 ad=3.36 pd=8 as=3.12 ps=7.6 w=1.2 l=0.6
C0 eval tail_ext 0.36751f
C1 tail_ext decision_p 0.48065f
C2 sar_readout_12b_0.vss iso_tail_ext 0.60045f
C3 reset decision_p 0.376f
C4 decision_n decision_p 2.54301f
C5 sar_comparator_input row_drive 5.27715f
C6 shared_converter_mux_0.mux_bus row_drive 0.06281f
C7 vdd_ext sar_readout_12b_0.vdd 1.39936f
C8 vdd_ext preamp_iso_tail_ext 0.83165f
C9 vdd_ext vss 0.68019f
C10 row_drive vdd 0.1964f
C11 row_drive row_dac_10b_0.vdd 1.11462f
C12 sar_readout_12b_0.vss row_drive 0.29422f
C13 vdd_ext iso_tail_ext 1.11354f
C14 row_drive row_dac_10b_0.vss 1.08123f
C15 shared_converter_mux_0.vss vdd_ext 0
C16 reset tail_ext 0.17577f
C17 decision_n tail_ext 0.48065f
C18 reset decision_n 0.31048f
C19 iso_tail_ext sar_readout_12b_0.vdd 0.27521f
C20 eval vdd_ext 0
C21 decision_p vdd_ext 4.01248f
C22 shared_converter_mux_0.vdd vdd_ext 0
C23 row_dac_10b_0.vdd row_dac_10b_0.vss 0.78467f
C24 row_drive vdd_ext 3.24962f
C25 sar_comparator_input vdd_ext 1.42179f
C26 shared_converter_mux_0.vdd vss 0.2816f
C27 shared_converter_mux_0.mux_bus vdd_ext 0.00217f
C28 row_drive sar_readout_12b_0.vdd 0.57218f
C29 row_drive preamp_iso_tail_ext 0.14919f
C30 sar_comparator_input preamp_iso_tail_ext 0.15093f
C31 tail_ext vdd_ext 2.05239f
C32 reset vdd_ext 4.48789f
C33 row_drive vss 0.22445f
C34 decision_n vdd_ext 4.12248f
C35 shared_converter_mux_0.mux_bus vss 0.03132f
C36 row_drive iso_tail_ext 1.97962f
C37 sar_comparator_input iso_tail_ext 0.16721f
C38 row_drive shared_converter_mux_0.vss 0.00246f
C39 sar_readout_12b_0.vss vdd_ext 0.93663f
C40 shared_converter_mux_0.mux_bus shared_converter_mux_0.vss 1.56188f
C41 sar_readout_12b_0.vss sar_readout_12b_0.vdd 0.49712f
C42 shared_converter_mux_0.vdd row_drive 0.00246f
C43 shared_converter_mux_0.vdd shared_converter_mux_0.mux_bus 1.55306f
C44 vss vss_escape 36.2211f
C45 vdd vss_escape 36.7f
C46 preamp_iso_tail_ext vss_escape 37.79194f
C47 iso_tail_ext vss_escape 22.0483f
C48 decision_p vss_escape 41.58859f
C49 tail_ext vss_escape 0.31959p
C50 vdd_ext vss_escape 24.27651f
C51 sar_readout_12b_0.vss vss_escape 1.33686f ; **FLOATING
C52 row_dac_10b_0.vss vss_escape 1.40333f ; **FLOATING
C53 row_dac_10b_0.vdd vss_escape 1.33457f ; **FLOATING
C54 sar_readout_12b_0.vdd vss_escape 1.77614f ; **FLOATING
C55 shared_converter_mux_0.vss vss_escape 1.39454f ; **FLOATING
C56 shared_converter_mux_0.mux_bus vss_escape 2.86922f ; **FLOATING
C57 shared_converter_mux_0.vdd vss_escape 0.95985f ; **FLOATING
.ends
