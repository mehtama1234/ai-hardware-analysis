* HYPOTHETICAL CONNECTIVITY DIAGNOSTIC; NOT AN EXTRACTED LAYOUT REVISION
* NGSPICE file created from aimc_converter_macro_active_candidate_flat.ext - technology: sky130A

.subckt aimc_converter_macro_active_candidate_flat vss vdd row_drive sar_comparator_input
+ decision_p decision_n reset eval vss_escape latch_sense_p_ext latch_sense_n_ext
+ iso_tail_ext tail_ext vdd_ext preamp_iso_tail_ext
X0 preamp_iso_tail_ext sar_comparator_input latch_sense_n_ext vss_escape sky130_fd_pr__nfet_01v8 ad=3.12 pd=7.6 as=3.36 ps=8 w=1.2 l=0.6
X1 vdd_ext decision_p decision_n vdd_ext sky130_fd_pr__pfet_01v8 ad=3.12 pd=7.6 as=3.36 ps=8 w=1.2 l=0.6
X2 tail_ext eval vss_escape vss_escape sky130_fd_pr__nfet_01v8 ad=16.2 pd=17.4 as=16.2 ps=17.4 w=6 l=0.6
X3 latch_sense_p_ext row_drive preamp_iso_tail_ext vss_escape sky130_fd_pr__nfet_01v8 ad=3.36 pd=8 as=3.12 ps=7.6 w=1.2 l=0.6
X4 decision_p latch_sense_p_ext tail_ext vss_escape sky130_fd_pr__nfet_01v8 ad=3.36 pd=8 as=3.12 ps=7.6 w=1.2 l=0.6
X5 vdd_ext reset decision_n vdd_ext sky130_fd_pr__pfet_01v8 ad=3.12 pd=7.6 as=3.36 ps=8 w=1.2 l=0.6
X6 tail_ext latch_sense_n_ext decision_n vss_escape sky130_fd_pr__nfet_01v8 ad=3.12 pd=7.6 as=3.36 ps=8 w=1.2 l=0.6
X7 decision_p decision_n vdd_ext vdd_ext sky130_fd_pr__pfet_01v8 ad=3.36 pd=8 as=3.12 ps=7.6 w=1.2 l=0.6
X8 tail_ext decision_p decision_n vss_escape sky130_fd_pr__nfet_01v8 ad=3.12 pd=7.6 as=3.36 ps=8 w=1.2 l=0.6
X9 latch_sense_p_ext row_drive iso_tail_ext vss_escape sky130_fd_pr__nfet_01v8 ad=3.36 pd=8 as=3.12 ps=7.6 w=1.2 l=0.6
X10 iso_tail_ext sar_comparator_input latch_sense_n_ext vss_escape sky130_fd_pr__nfet_01v8 ad=3.12 pd=7.6 as=3.36 ps=8 w=1.2 l=0.6
X11 decision_p reset vdd_ext vdd_ext sky130_fd_pr__pfet_01v8 ad=3.36 pd=8 as=3.12 ps=7.6 w=1.2 l=0.6
X12 decision_p decision_n tail_ext vss_escape sky130_fd_pr__nfet_01v8 ad=3.36 pd=8 as=3.12 ps=7.6 w=1.2 l=0.6
C0 sar_comparator_input vdd_ext 0.0039f
C1 sar_readout_12b_0.vss vdd_ext 0.93663f
C2 shared_converter_mux_0.vdd shared_converter_mux_0.mux_bus 1.55306f
C3 shared_converter_mux_0.vss shared_converter_mux_0.mux_bus 1.56188f
C4 m2_64900_1400# preamp_iso_tail_ext 0.34398f
C5 tail_ext vdd_ext 1.9856f
C6 reset vdd_ext 4.48789f
C7 latch_sense_p_ext preamp_iso_tail_ext 0.05749f
C8 shared_converter_mux_0.vdd row_drive 0.00246f
C9 latch_sense_n_ext preamp_iso_tail_ext 0.05717f
C10 row_drive m2_64900_1400# 0.03637f
C11 shared_converter_mux_0.vss row_drive 0.00246f
C12 row_drive latch_sense_n_ext 0.20099f
C13 sar_comparator_input iso_tail_ext 0.16721f
C14 m2_64900_1400# row_drive 0.00382f
C15 row_drive latch_sense_p_ext 0.02157f
C16 vdd row_drive 0.1964f
C17 sar_readout_12b_0.vss iso_tail_ext 0.60045f
C18 latch_sense_p_ext row_drive 0.00133f
C19 sar_comparator_input sar_comparator_input 0.07548f
C20 vdd_ext latch_sense_p_ext 3.43095f
C21 latch_sense_n_ext decision_n 0.18428f
C22 preamp_iso_tail_ext vdd_ext 0.30357f
C23 shared_converter_mux_0.mux_bus vdd_ext 0.00217f
C24 row_drive vdd_ext 0.03284f
C25 decision_p vdd_ext 3.8282f
C26 vdd_ext row_drive 2.69688f
C27 reset tail_ext 0.17577f
C28 vss latch_sense_p_ext 0.23329f
C29 iso_tail_ext latch_sense_p_ext 0.12577f
C30 shared_converter_mux_0.mux_bus vss 0.03132f
C31 preamp_iso_tail_ext sar_comparator_input 0.03759f
C32 sar_readout_12b_0.vdd vdd_ext 1.39936f
C33 vdd_ext decision_n 3.9382f
C34 vss row_drive 0.22445f
C35 iso_tail_ext row_drive 1.97962f
C36 m2_64900_1400# latch_sense_p_ext 0.41846f
C37 sar_comparator_input preamp_iso_tail_ext 0.11179f
C38 row_drive sar_comparator_input 0.04049f
C39 m2_64900_1400# latch_sense_n_ext 0.41846f
C40 eval vdd_ext 0
C41 tail_ext latch_sense_p_ext 0.0334f
C42 sar_comparator_input row_drive 5.23145f
C43 latch_sense_p_ext latch_sense_n_ext 0.00782f
C44 sar_readout_12b_0.vss row_drive 0.29422f
C45 sar_readout_12b_0.vdd iso_tail_ext 0.27521f
C46 tail_ext decision_p 0.48065f
C47 shared_converter_mux_0.vdd vdd_ext 0
C48 reset decision_p 0.376f
C49 shared_converter_mux_0.vss vdd_ext 0
C50 vdd_ext latch_sense_n_ext 3.48444f
C51 m2_64900_1400# vdd_ext 0.07266f
C52 latch_sense_p_ext vdd_ext 0.02484f
C53 latch_sense_n_ext vdd_ext 0.0106f
C54 sar_readout_12b_0.vdd sar_readout_12b_0.vss 0.49712f
C55 row_dac_10b_0.vss row_drive 1.08123f
C56 shared_converter_mux_0.vdd vss 0.2816f
C57 tail_ext decision_n 0.48065f
C58 vss latch_sense_n_ext 0.23329f
C59 reset decision_n 0.31048f
C60 iso_tail_ext latch_sense_n_ext 0.12577f
C61 decision_p latch_sense_p_ext 0.18428f
C62 row_drive preamp_iso_tail_ext 0.12292f
C63 tail_ext eval 0.36751f
C64 row_drive latch_sense_p_ext 0.24412f
C65 preamp_iso_tail_ext row_drive 0.02471f
C66 sar_comparator_input latch_sense_n_ext 0.04279f
C67 shared_converter_mux_0.mux_bus row_drive 0.06281f
C68 m2_64900_1400# sar_comparator_input 0.1759f
C69 row_dac_10b_0.vdd row_dac_10b_0.vss 0.78467f
C70 row_drive row_drive 0.08156f
C71 latch_sense_p_ext sar_comparator_input 0.02717f
C72 m2_64900_1400# sar_comparator_input 0.03955f
C73 latch_sense_n_ext sar_comparator_input 0.0285f
C74 tail_ext latch_sense_n_ext 0.0334f
C75 sar_comparator_input latch_sense_n_ext 0.02157f
C76 vss vdd_ext 0.21361f
C77 vdd_ext iso_tail_ext 0.86179f
C78 decision_p decision_n 2.54301f
C79 sar_readout_12b_0.vdd row_drive 0.57218f
C80 row_dac_10b_0.vdd row_drive 1.11462f
C81 sar_comparator_input vdd_ext 1.05718f
C82 vss vss_escape 36.2211f
C83 vdd vss_escape 36.7f
C84 preamp_iso_tail_ext vss_escape 4.23749f
C85 iso_tail_ext vss_escape 55.47765f
C86 latch_sense_n_ext vss_escape 8.9128f
C87 latch_sense_p_ext vss_escape 24.51655f
C88 decision_p vss_escape 7.45999f
C89 tail_ext vss_escape 81.67176f
C90 vdd_ext vss_escape 0.25966p
C91 m2_64900_1400# vss_escape 0.72762f ; **FLOATING
C92 sar_readout_12b_0.vss vss_escape 1.33686f ; **FLOATING
C93 row_dac_10b_0.vss vss_escape 1.40333f ; **FLOATING
C94 row_dac_10b_0.vdd vss_escape 1.33457f ; **FLOATING
C95 sar_readout_12b_0.vdd vss_escape 1.77614f ; **FLOATING
C96 shared_converter_mux_0.vss vss_escape 1.39454f ; **FLOATING
C97 shared_converter_mux_0.mux_bus vss_escape 2.86922f ; **FLOATING
C98 shared_converter_mux_0.vdd vss_escape 0.95985f ; **FLOATING
C99 latch_sense_n_ext vss_escape 1.04634f
C100 latch_sense_p_ext vss_escape 1.04634f
.ends
