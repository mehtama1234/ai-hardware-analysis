* NGSPICE file created from sky130_isolated_frontend_active_load_latch_v2.ext - technology: sky130A

X0 latch_sense_p sense_p iso_tail vss sky130_fd_pr__nfet_01v8 ad=3.36 pd=8 as=3.12 ps=7.6 w=1.2 l=0.6
X1 out_p out_n tail vss sky130_fd_pr__nfet_01v8 ad=3.36 pd=8 as=3.12 ps=7.6 w=1.2 l=0.6
X2 out_n latch_sense_n tail vss sky130_fd_pr__nfet_01v8 ad=3.36 pd=8 as=3.12 ps=7.6 w=1.2 l=0.6
X3 out_n out_p vdd_active vdd_active sky130_fd_pr__pfet_01v8 ad=3.36 pd=8 as=3.12 ps=7.6 w=1.2 l=0.6
X4 iso_tail sense_n latch_sense_n vss sky130_fd_pr__nfet_01v8 ad=3.12 pd=7.6 as=3.36 ps=8 w=1.2 l=0.6
X5 out_n out_p tail vss sky130_fd_pr__nfet_01v8 ad=3.36 pd=8 as=3.12 ps=7.6 w=1.2 l=0.6
X6 out_n reset vdd vdd sky130_fd_pr__pfet_01v8 ad=3.36 pd=8 as=3.12 ps=7.6 w=1.2 l=0.6
X7 out_p latch_sense_p tail vss sky130_fd_pr__nfet_01v8 ad=3.36 pd=8 as=3.12 ps=7.6 w=1.2 l=0.6
X8 tail eval vss vss sky130_fd_pr__nfet_01v8 ad=16.8 pd=17.6 as=15.6 ps=17.2 w=6 l=0.6
X9 out_p out_n vdd_active vdd_active sky130_fd_pr__pfet_01v8 ad=3.36 pd=8 as=3.12 ps=7.6 w=1.2 l=0.6
X10 out_p reset vdd vdd sky130_fd_pr__pfet_01v8 ad=3.36 pd=8 as=3.12 ps=7.6 w=1.2 l=0.6
C0 out_p vdd_active 4.31746f
C1 reset out_n 0.05967f
C2 sense_p latch_sense_p 0.06485f
C3 eval out_n 0.02298f
C4 sense_n latch_sense_n 0.05507f
C5 out_p latch_sense_n 1.00043f
C6 tail out_p 3.33055f
C7 iso_tail latch_sense_p 0.09804f
C8 latch_sense_n m1_3440_12500# 0.0106f
C9 tail eval 0.09415f
C10 out_n vdd 0.95698f
C11 iso_tail latch_sense_n 0.15122f
C12 reset out_p 0.07615f
C13 sense_p m1_1000_12500# 0.04904f
C14 out_n latch_sense_p 0.27084f
C15 eval out_p 0.04062f
C16 vdd_active latch_sense_p 0.50449f
C17 out_n vdd_active 5.52673f
C18 sense_n m1_3440_12500# 0.04904f
C19 iso_tail m1_1000_12500# 0.00302f
C20 sense_n iso_tail 0.11179f
C21 latch_sense_n latch_sense_p 0.0207f
C22 out_n latch_sense_n 1.04924f
C23 vdd_active latch_sense_n 0.53393f
C24 tail latch_sense_p 0.36163f
C25 tail out_n 2.28538f
C26 sense_p iso_tail 0.12292f
C27 out_p vdd 1.0487f
C28 iso_tail m1_3440_12500# 0.00302f
C29 latch_sense_p m1_1000_12500# 0.05106f
C30 reset vdd 4.28849f
C31 out_p latch_sense_p 0.32159f
C32 out_p out_n 1.85382f
C33 tail latch_sense_n 0.4349f
C34 reset vss 0.8786f
C35 tail vss 10.0187f
C36 eval vss 1.1758f
C37 out_p vss 15.1647f
C38 out_n vss 16.2693f
C39 latch_sense_n vss 9.45522f
C40 latch_sense_p vss 6.9417f
C41 iso_tail vss 2.81735f
C42 sense_n vss 1.42522f
C43 sense_p vss 1.42522f
C44 vdd vss 30.6807f
C45 vdd_active vss 45.577f
C46 m1_3440_12500# vss 0.33861f
C47 m1_1000_12500# vss 0.33861f
