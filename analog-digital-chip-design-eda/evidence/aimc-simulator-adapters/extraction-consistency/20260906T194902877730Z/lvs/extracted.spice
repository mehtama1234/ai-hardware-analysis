* NGSPICE file created from sky130_isolated_frontend_active_load_latch_v2.ext - technology: sky130A

.subckt sky130_isolated_frontend_active_load_latch_v2 out_p out_n latch_sense_p latch_sense_n
+ tail reset vdd vss eval sense_p sense_n iso_tail vdd_active
X0 latch_sense_p sense_p iso_tail vss sky130_fd_pr__nfet_01v8 ad=3.36 pd=8 as=3.12 ps=7.6 w=1.2 l=0.6
X1 out_p out_n tail vss sky130_fd_pr__nfet_01v8 ad=3.36 pd=8 as=3.12 ps=7.6 w=1.2 l=0.6
X2 out_n latch_sense_n tail vss sky130_fd_pr__nfet_01v8 ad=3.36 pd=8 as=3.12 ps=7.6 w=1.2 l=0.6
X3 out_n out_p vdd_active vdd_active sky130_fd_pr__pfet_01v8 ad=3.36 pd=8 as=3.12 ps=7.6 w=1.2 l=0.6
X4 iso_tail sense_n latch_sense_n vss sky130_fd_pr__nfet_01v8 ad=3.12 pd=7.6 as=3.36 ps=8 w=1.2 l=0.6
X5 out_n out_p tail vss sky130_fd_pr__nfet_01v8 ad=3.36 pd=8 as=3.12 ps=7.6 w=1.2 l=0.6
X6 out_n reset vdd vdd sky130_fd_pr__pfet_01v8 ad=3.36 pd=8 as=3.12 ps=7.6 w=1.2 l=0.6
X7 out_p latch_sense_p tail vss sky130_fd_pr__nfet_01v8 ad=3.36 pd=8 as=3.12 ps=7.6 w=1.2 l=0.6
X8 tail eval vss vss sky130_fd_pr__nfet_01v8 ad=16.8 pd=17.6 as=15.6 ps=17.2 w=6 l=0.6
X9 out_p out_n vdd_active vdd_active sky130_fd_pr__pfet_01v8 ad=3.36 pd=8 as=3.12 ps=7.6 w=1.2 l=0.6
X10 out_p reset vdd vdd sky130_fd_pr__pfet_01v8 ad=3.36 pd=8 as=3.12 ps=7.6 w=1.2 l=0.6
C0 reset vdd 4.28849f
C1 out_p latch_sense_p 0.32159f
C2 out_p out_n 1.85382f
C3 tail latch_sense_n 0.4349f
C4 out_p vdd_active 4.31746f
C5 reset out_n 0.05967f
C6 sense_p latch_sense_p 0.06485f
C7 eval out_n 0.02298f
C8 sense_n latch_sense_n 0.05507f
C9 out_p latch_sense_n 1.00043f
C10 iso_tail latch_sense_p 0.09804f
C11 tail out_p 3.33055f
C12 latch_sense_n m1_3440_12500# 0.0106f
C13 tail eval 0.09415f
C14 out_n vdd 0.95698f
C15 iso_tail latch_sense_n 0.15122f
C16 reset out_p 0.07615f
C17 sense_p m1_1000_12500# 0.04904f
C18 out_n latch_sense_p 0.27084f
C19 eval out_p 0.04062f
C20 vdd_active latch_sense_p 0.50449f
C21 out_n vdd_active 5.52673f
C22 sense_n m1_3440_12500# 0.04904f
C23 iso_tail m1_1000_12500# 0.00302f
C24 sense_n iso_tail 0.11179f
C25 latch_sense_n latch_sense_p 0.0207f
C26 out_n latch_sense_n 1.04924f
C27 vdd_active latch_sense_n 0.53393f
C28 tail latch_sense_p 0.36163f
C29 tail out_n 2.28538f
C30 sense_p iso_tail 0.12292f
C31 out_p vdd 1.0487f
C32 iso_tail m1_3440_12500# 0.00302f
C33 latch_sense_p m1_1000_12500# 0.05106f
C34 tail vss 27.29601f
C35 out_p vss 12.23545f
C36 latch_sense_n vss 0.71261f
C37 iso_tail vss 4.24257f
C38 vdd vss 31.12f
C39 vdd_active vss 65.63497f
C40 m1_3440_12500# vss 0.33861f ; **FLOATING
C41 m1_1000_12500# vss 0.33861f ; **FLOATING
.ends
