* NGSPICE file created from sky130_isolated_frontend_active_load_latch_v2.ext - technology: sky130A

.subckt sky130_isolated_frontend_active_load_latch_v2 latch_sense_p latch_sense_n
+ tail reset vdd vss eval sense_p sense_n iso_tail vdd_active
X0 tail tail vdd_active vdd_active sky130_fd_pr__pfet_01v8 ad=6.72 pd=10.4 as=6.24 ps=10 w=2.4 l=0.6
X1 vdd reset tail vdd sky130_fd_pr__pfet_01v8 ad=3.12 pd=7.6 as=3.36 ps=8 w=1.2 l=0.6
X2 tail tail tail vss sky130_fd_pr__nfet_01v8 ad=32.94 pd=34.2 as=147.96001 ps=154.2 w=5.1 l=0.6
X3 tail reset vdd vdd sky130_fd_pr__pfet_01v8 ad=3.36 pd=8 as=3.12 ps=7.6 w=1.2 l=0.6
X4 tail tail tail vss sky130_fd_pr__nfet_01v8 ad=32.94 pd=34.2 as=0 ps=0 w=5.1 l=0.6
X5 tail latch_sense_n tail vss sky130_fd_pr__nfet_01v8 ad=32.94 pd=34.2 as=0 ps=0 w=5.1 l=0.6
X6 tail eval vss vss sky130_fd_pr__nfet_01v8 ad=16.2 pd=17.4 as=16.2 ps=17.4 w=6 l=0.6
X7 tail latch_sense_p tail vss sky130_fd_pr__nfet_01v8 ad=32.94 pd=34.2 as=0 ps=0 w=5.1 l=0.6
X8 iso_tail sense_n latch_sense_n vss sky130_fd_pr__nfet_01v8 ad=3.12 pd=7.6 as=3.36 ps=8 w=1.2 l=0.6
X9 vdd_active tail tail vdd_active sky130_fd_pr__pfet_01v8 ad=6.24 pd=10 as=6.72 ps=10.4 w=2.4 l=0.6
X10 latch_sense_p sense_p iso_tail vss sky130_fd_pr__nfet_01v8 ad=3.36 pd=8 as=3.12 ps=7.6 w=1.2 l=0.6
C0 reset vdd 4.03064f
C1 latch_sense_p sense_p 0.02861f
C2 latch_sense_n tail 0.1924f
C3 iso_tail latch_sense_n 0.07366f
C4 vdd_active tail 6.6482f
C5 eval tail 0.09547f
C6 latch_sense_n sense_n 0.02861f
C7 reset tail 0.62096f
C8 iso_tail sense_n 0.03465f
C9 iso_tail sense_p 0.03465f
C10 latch_sense_p tail 0.1924f
C11 iso_tail latch_sense_p 0.07366f
C12 vdd tail 2.47284f
C13 iso_tail vss 21.8637f
C14 sense_n vss 1.81302f
C15 sense_p vss 1.81302f
C16 latch_sense_n vss 6.84318f
C17 latch_sense_p vss 6.84318f
C18 reset vss 5.38674f
C19 tail vss 79.8961f
C20 eval vss 1.00307f
C21 vdd_active vss 65.9879f
C22 vdd vss 69.707f
.ends
