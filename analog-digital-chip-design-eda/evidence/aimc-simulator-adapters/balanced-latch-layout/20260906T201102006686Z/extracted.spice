* NGSPICE file created from sky130_isolated_frontend_active_load_latch_v2.ext - technology: sky130A

.subckt sky130_isolated_frontend_active_load_latch_v2 out_p out_n latch_sense_p latch_sense_n
+ reset vdd vss eval sense_p sense_n iso_tail vdd_active
X0 out_p out_n vdd_active vdd_active sky130_fd_pr__pfet_01v8 ad=3.36 pd=8 as=3.12 ps=7.6 w=1.2 l=0.6
X1 vdd reset out_n vdd sky130_fd_pr__pfet_01v8 ad=3.12 pd=7.6 as=3.36 ps=8 w=1.2 l=0.6
X2 vss out_p out_n vss sky130_fd_pr__nfet_01v8 ad=3.12 pd=7.6 as=3.36 ps=8 w=1.2 l=0.6
X3 out_p reset vdd vdd sky130_fd_pr__pfet_01v8 ad=3.36 pd=8 as=3.12 ps=7.6 w=1.2 l=0.6
X4 out_p out_n vss vss sky130_fd_pr__nfet_01v8 ad=3.36 pd=8 as=3.12 ps=7.6 w=1.2 l=0.6
X5 vss latch_sense_n out_n vss sky130_fd_pr__nfet_01v8 ad=3.12 pd=7.6 as=3.36 ps=8 w=1.2 l=0.6
X6 vss eval vss vss sky130_fd_pr__nfet_01v8 ad=16.2 pd=17.4 as=44.88 ps=65.2 w=6 l=0.6
X7 out_p latch_sense_p vss vss sky130_fd_pr__nfet_01v8 ad=3.36 pd=8 as=3.12 ps=7.6 w=1.2 l=0.6
X8 iso_tail sense_n latch_sense_n vss sky130_fd_pr__nfet_01v8 ad=3.12 pd=7.6 as=3.36 ps=8 w=1.2 l=0.6
X9 vdd_active out_p out_n vdd_active sky130_fd_pr__pfet_01v8 ad=3.12 pd=7.6 as=3.36 ps=8 w=1.2 l=0.6
X10 latch_sense_p sense_p iso_tail vss sky130_fd_pr__nfet_01v8 ad=3.36 pd=8 as=3.12 ps=7.6 w=1.2 l=0.6
C0 latch_sense_n iso_tail 0.07366f
C1 out_p vdd 0.76206f
C2 latch_sense_p iso_tail 0.07366f
C3 sense_p latch_sense_p 0.02861f
C4 latch_sense_n sense_n 0.02861f
C5 sense_p iso_tail 0.03465f
C6 out_p reset 0.31048f
C7 out_p latch_sense_p 0.15098f
C8 out_p vdd_active 3.11392f
C9 out_n vdd 0.76206f
C10 latch_sense_n out_n 0.15098f
C11 iso_tail sense_n 0.03465f
C12 out_n reset 0.31048f
C13 out_n vdd_active 2.96656f
C14 out_n out_p 2.54301f
C15 vdd reset 4.03064f
C16 iso_tail vss 21.8637f
C17 sense_n vss 1.81302f
C18 sense_p vss 1.81302f
C19 latch_sense_n vss 7.59749f
C20 latch_sense_p vss 7.59749f
C21 out_n vss 20.0269f
C22 out_p vss 20.1702f
C23 reset vss 5.38674f
C24 eval vss 1.09855f
C25 vdd_active vss 67.0816f
C26 vdd vss 70.6557f
.ends
