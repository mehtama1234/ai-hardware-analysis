* NGSPICE file created from sky130_isolated_frontend_active_load_latch_v2.ext - technology: sky130A

.subckt sky130_isolated_frontend_active_load_latch_v2 out_p out_n latch_sense_p latch_sense_n
+ tail reset vdd vss eval sense_p sense_n iso_tail vdd_active
X0 out_p out_n vdd_active vdd_active sky130_fd_pr__pfet_01v8 ad=6.72 pd=10.4 as=6.24 ps=10 w=2.4 l=0.6
X1 vdd reset out_n vdd sky130_fd_pr__pfet_01v8 ad=3.12 pd=7.6 as=3.36 ps=8 w=1.2 l=0.6
X2 tail out_p out_n vss sky130_fd_pr__nfet_01v8 ad=12.48 pd=14.8 as=13.44 ps=15.2 w=4.8 l=0.6
X3 out_p reset vdd vdd sky130_fd_pr__pfet_01v8 ad=3.36 pd=8 as=3.12 ps=7.6 w=1.2 l=0.6
X4 out_p out_n tail vss sky130_fd_pr__nfet_01v8 ad=13.44 pd=15.2 as=12.48 ps=14.8 w=4.8 l=0.6
X5 tail latch_sense_n out_n vss sky130_fd_pr__nfet_01v8 ad=12.48 pd=14.8 as=13.44 ps=15.2 w=4.8 l=0.6
X6 tail eval vss vss sky130_fd_pr__nfet_01v8 ad=16.2 pd=17.4 as=16.2 ps=17.4 w=6 l=0.6
X7 out_p latch_sense_p tail vss sky130_fd_pr__nfet_01v8 ad=13.44 pd=15.2 as=12.48 ps=14.8 w=4.8 l=0.6
X8 iso_tail sense_n latch_sense_n vss sky130_fd_pr__nfet_01v8 ad=3.12 pd=7.6 as=3.36 ps=8 w=1.2 l=0.6
X9 vdd_active out_p out_n vdd_active sky130_fd_pr__pfet_01v8 ad=6.24 pd=10 as=6.72 ps=10.4 w=2.4 l=0.6
X10 latch_sense_p sense_p iso_tail vss sky130_fd_pr__nfet_01v8 ad=3.36 pd=8 as=3.12 ps=7.6 w=1.2 l=0.6
C0 out_p tail 0.51868f
C1 out_p out_n 2.60132f
C2 out_p vdd_active 2.82313f
C3 latch_sense_p sense_p 0.02861f
C4 iso_tail latch_sense_p 0.07366f
C5 sense_n iso_tail 0.10725f
C6 out_p reset 0.31048f
C7 latch_sense_p out_p 0.1874f
C8 vdd tail 0.94872f
C9 out_n vdd 0.76206f
C10 tail latch_sense_n 0.0334f
C11 out_n latch_sense_n 0.1874f
C12 reset vdd 4.03064f
C13 iso_tail sense_p 0.10725f
C14 sense_n latch_sense_n 0.02861f
C15 out_n tail 0.51868f
C16 vdd_active tail 0.94872f
C17 eval tail 0.09547f
C18 out_n vdd_active 2.87636f
C19 reset out_n 0.31048f
C20 latch_sense_p tail 0.0334f
C21 iso_tail latch_sense_n 0.07366f
C22 out_p vdd 0.76206f
C23 iso_tail vss 21.8079f
C24 sense_n vss 3.99067f
C25 sense_p vss 3.99067f
C26 latch_sense_n vss 6.92861f
C27 latch_sense_p vss 6.92861f
C28 out_n vss 22.2747f
C29 out_p vss 22.3041f
C30 reset vss 5.38674f
C31 tail vss 41.9821f
C32 eval vss 1.00307f
C33 vdd_active vss 65.9879f
C34 vdd vss 69.707f
.ends
