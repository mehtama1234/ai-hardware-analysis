* Intended circuit, written independently of extraction ordering.
* Sense pair drains drive the latch inputs; active load uses separate supply.
.subckt sky130_isolated_frontend_active_load_latch_v2 out_p out_n latch_sense_p
+ latch_sense_n tail reset vdd vss eval sense_p sense_n iso_tail vdd_active
Xiso_p latch_sense_p sense_p iso_tail vss sky130_fd_pr__nfet_01v8 w=1.2 l=0.6
Xiso_n latch_sense_n sense_n iso_tail vss sky130_fd_pr__nfet_01v8 w=1.2 l=0.6
Xsense_p out_p latch_sense_p tail vss sky130_fd_pr__nfet_01v8 w=1.2 l=0.6
Xsense_n out_n latch_sense_n tail vss sky130_fd_pr__nfet_01v8 w=1.2 l=0.6
Xfeedback_p out_p out_n tail vss sky130_fd_pr__nfet_01v8 w=1.2 l=0.6
Xfeedback_n out_n out_p tail vss sky130_fd_pr__nfet_01v8 w=1.2 l=0.6
Xtail tail eval vss vss sky130_fd_pr__nfet_01v8 w=6 l=0.6
Xload_p out_p out_n vdd_active vdd_active sky130_fd_pr__pfet_01v8 w=1.2 l=0.6
Xload_n out_n out_p vdd_active vdd_active sky130_fd_pr__pfet_01v8 w=1.2 l=0.6
Xreset_p out_p reset vdd vdd sky130_fd_pr__pfet_01v8 w=1.2 l=0.6
Xreset_n out_n reset vdd vdd sky130_fd_pr__pfet_01v8 w=1.2 l=0.6
.ends sky130_isolated_frontend_active_load_latch_v2
