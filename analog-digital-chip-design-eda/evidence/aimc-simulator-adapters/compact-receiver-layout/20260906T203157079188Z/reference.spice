* Independently specified compact receiver, W/L in micrometres.
.subckt compact_receiver input output vdd vss
XN output input vss vss sky130_fd_pr__nfet_01v8 w=0.42 l=0.15
XP output input vdd vdd sky130_fd_pr__pfet_01v8 w=0.42 l=0.15
.ends compact_receiver
