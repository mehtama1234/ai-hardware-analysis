* NGSPICE file created from compact_receiver.ext - technology: sky130A

.subckt compact_receiver
X0 a_15_n42# a_n33_n139# a_n73_n42# w_n211_n261# sky130_fd_pr__pfet_01v8 ad=0.1218 pd=1.42 as=0.1218 ps=1.42 w=0.42 l=0.15
C0 a_n73_n42# a_15_n42# 0.03727f
C1 a_n73_n42# w_n211_n261# 0.03728f
C2 w_n211_n261# a_15_n42# 0.03728f
C3 a_n73_n42# a_n33_n139# 0.01702f
C4 a_n33_n139# a_15_n42# 0.01702f
C5 a_n33_n139# w_n211_n261# 0.23258f
C6 a_15_n42# VSUBS 0.02195f ; **FLOATING
C7 a_n73_n42# VSUBS 0.02195f ; **FLOATING
C8 a_n33_n139# VSUBS 0.09533f ; **FLOATING
C9 w_n211_n261# VSUBS 0.95181f ; **FLOATING
.ends
