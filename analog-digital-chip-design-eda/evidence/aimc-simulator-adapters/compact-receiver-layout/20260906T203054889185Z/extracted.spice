* NGSPICE file created from compact_receiver.ext - technology: sky130A

.subckt compact_receiver input output vdd vss
X0 output input vss vss sky130_fd_pr__nfet_01v8 ad=0.1218 pd=1.42 as=0.1218 ps=1.42 w=0.42 l=0.15
X1 output input vdd vdd sky130_fd_pr__pfet_01v8 ad=0.1218 pd=1.42 as=0.1218 ps=1.42 w=0.42 l=0.15
C0 input output 0.04945f
C1 input vdd 0.38269f
C2 vdd output 0.13777f
C3 output vss 0.74468f
C4 input vss 1.00905f
C5 vdd vss 1.06401f
.ends
