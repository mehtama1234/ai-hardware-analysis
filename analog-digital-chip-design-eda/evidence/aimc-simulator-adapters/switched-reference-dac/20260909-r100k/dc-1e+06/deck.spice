* Candidate 8-bit reference DAC: ideal resistors, SKY130 transmission gates.
.option scale=1u
.param mc_mm_switch=0 mc_pr_switch=0
.include "/home/mehtama1/eda-tools/pdks/sky130A/libs.ref/sky130_fd_pr/spice/sky130_fd_pr__nfet_01v8__tt.pm3.spice"
.include "/home/mehtama1/eda-tools/pdks/sky130A/libs.ref/sky130_fd_pr/spice/sky130_fd_pr__nfet_01v8__mismatch.corner.spice"
.include "/home/mehtama1/eda-tools/pdks/sky130A/libs.ref/sky130_fd_pr/spice/sky130_fd_pr__pfet_01v8__tt.corner.spice"
.include "/home/mehtama1/eda-tools/pdks/sky130A/libs.ref/sky130_fd_pr/spice/sky130_fd_pr__pfet_01v8__mismatch.corner.spice"
* SKY130 Spice File.
.option scale=1.0u
.include "/home/mehtama1/eda-tools/pdks/sky130A/libs.tech/ngspice/parameters/lod.spice"
.param
+ lv_dlc_rotweak = .00e-9
+ lvhvt_dlc_rotweak = .00e-9
+ lvt_dlc_rotweak = .00e-9
+ hv_dlc_rotweak = .00e-9
+ sky130_fd_pr__nfet_01v8__dlc_rotweak = lv_dlc_rotweak
+ sky130_fd_pr__esd_nfet_01v8__dlc_rotweak = lv_dlc_rotweak
+ sky130_fd_pr__nfet_01v8_lvt__dlc_rotweak = lvt_dlc_rotweak
+ sky130_fd_pr__pfet_01v8__dlc_rotweak = lv_dlc_rotweak
+ sky130_fd_pr__pfet_01v8_lvt__dlc_rotweak = lvt_dlc_rotweak
+ sky130_fd_pr__pfet_01v8_hvt__dlc_rotweak = lvhvt_dlc_rotweak
+ sky130_fd_pr__esd_nfet_g5v0d10v5__dlc_rotweak = hv_dlc_rotweak
+ sky130_fd_pr__esd_pfet_g5v0d10v5__dlc_rotweak = hv_dlc_rotweak
+ sky130_fd_pr__nfet_03v3_nvt__dlc_rotweak = hv_dlc_rotweak
+ sky130_fd_pr__nfet_05v0_nvt__dlc_rotweak = hv_dlc_rotweak
+ sky130_fd_pr__nfet_g5v0d10v5__dlc_rotweak = hv_dlc_rotweak
+ sky130_fd_pr__pfet_g5v0d10v5__dlc_rotweak = hv_dlc_rotweak
+ sky130_fd_pr__pfet_g5v0d16v0__dlc_rotweak = hv_dlc_rotweak
+ sky130_fd_pr__special_nfet_pass__dlc_rotweak = lv_dlc_rotweak
+ sky130_fd_pr__special_nfet_pass_lowleakage__dlc_rotweak = lv_dlc_rotweak
+ sky130_fd_pr__special_nfet_pass_flash__dlc_rotweak = hv_dlc_rotweak
+ sky130_fd_pr__special_nfet_latch__dlc_rotweak = lv_dlc_rotweak
+ sky130_fd_pr__special_nfet_latch_lowleakage__dlc_rotweak = lv_dlc_rotweak
+ sky130_fd_pr__special_pfet_latch__dlc_rotweak = lv_dlc_rotweak
+ sky130_fd_pr__special_pfet_latch_lowleakage__dlc_rotweak = lv_dlc_rotweak
+ sky130_fd_bs_flash__special_sonosfet_star__dlc_rotweak = hv_dlc_rotweak
+ sky130_fd_bs_flash__special_sonosfet_original__dlc_rotweak = hv_dlc_rotweak
+ sonos_eeol_dlc_rotweak = hv_dlc_rotweak
+ sonos_peol_dlc_rotweak = hv_dlc_rotweak

.temp 27
VDD vdd 0 1.8
VREF ref 0 1.2
VB0 b0 0 0
VB0bar b0bar 0 1.8
X0hn bit0 b0 ref 0 sky130_fd_pr__nfet_01v8 w=4 l=0.15
X0hp bit0 b0bar ref vdd sky130_fd_pr__pfet_01v8 w=8 l=0.15
X0ln bit0 b0bar 0 0 sky130_fd_pr__nfet_01v8 w=4 l=0.15
X0lp bit0 b0 0 vdd sky130_fd_pr__pfet_01v8 w=8 l=0.15
Rbranch0 n0 bit0 200000
Rseries0 n0 n1 100000
VB1 b1 0 0
VB1bar b1bar 0 1.8
X1hn bit1 b1 ref 0 sky130_fd_pr__nfet_01v8 w=4 l=0.15
X1hp bit1 b1bar ref vdd sky130_fd_pr__pfet_01v8 w=8 l=0.15
X1ln bit1 b1bar 0 0 sky130_fd_pr__nfet_01v8 w=4 l=0.15
X1lp bit1 b1 0 vdd sky130_fd_pr__pfet_01v8 w=8 l=0.15
Rbranch1 n1 bit1 200000
Rseries1 n1 n2 100000
VB2 b2 0 0
VB2bar b2bar 0 1.8
X2hn bit2 b2 ref 0 sky130_fd_pr__nfet_01v8 w=4 l=0.15
X2hp bit2 b2bar ref vdd sky130_fd_pr__pfet_01v8 w=8 l=0.15
X2ln bit2 b2bar 0 0 sky130_fd_pr__nfet_01v8 w=4 l=0.15
X2lp bit2 b2 0 vdd sky130_fd_pr__pfet_01v8 w=8 l=0.15
Rbranch2 n2 bit2 200000
Rseries2 n2 n3 100000
VB3 b3 0 0
VB3bar b3bar 0 1.8
X3hn bit3 b3 ref 0 sky130_fd_pr__nfet_01v8 w=4 l=0.15
X3hp bit3 b3bar ref vdd sky130_fd_pr__pfet_01v8 w=8 l=0.15
X3ln bit3 b3bar 0 0 sky130_fd_pr__nfet_01v8 w=4 l=0.15
X3lp bit3 b3 0 vdd sky130_fd_pr__pfet_01v8 w=8 l=0.15
Rbranch3 n3 bit3 200000
Rseries3 n3 n4 100000
VB4 b4 0 0
VB4bar b4bar 0 1.8
X4hn bit4 b4 ref 0 sky130_fd_pr__nfet_01v8 w=4 l=0.15
X4hp bit4 b4bar ref vdd sky130_fd_pr__pfet_01v8 w=8 l=0.15
X4ln bit4 b4bar 0 0 sky130_fd_pr__nfet_01v8 w=4 l=0.15
X4lp bit4 b4 0 vdd sky130_fd_pr__pfet_01v8 w=8 l=0.15
Rbranch4 n4 bit4 200000
Rseries4 n4 n5 100000
VB5 b5 0 0
VB5bar b5bar 0 1.8
X5hn bit5 b5 ref 0 sky130_fd_pr__nfet_01v8 w=4 l=0.15
X5hp bit5 b5bar ref vdd sky130_fd_pr__pfet_01v8 w=8 l=0.15
X5ln bit5 b5bar 0 0 sky130_fd_pr__nfet_01v8 w=4 l=0.15
X5lp bit5 b5 0 vdd sky130_fd_pr__pfet_01v8 w=8 l=0.15
Rbranch5 n5 bit5 200000
Rseries5 n5 n6 100000
VB6 b6 0 0
VB6bar b6bar 0 1.8
X6hn bit6 b6 ref 0 sky130_fd_pr__nfet_01v8 w=4 l=0.15
X6hp bit6 b6bar ref vdd sky130_fd_pr__pfet_01v8 w=8 l=0.15
X6ln bit6 b6bar 0 0 sky130_fd_pr__nfet_01v8 w=4 l=0.15
X6lp bit6 b6 0 vdd sky130_fd_pr__pfet_01v8 w=8 l=0.15
Rbranch6 n6 bit6 200000
Rseries6 n6 n7 100000
VB7 b7 0 0
VB7bar b7bar 0 1.8
X7hn bit7 b7 ref 0 sky130_fd_pr__nfet_01v8 w=4 l=0.15
X7hp bit7 b7bar ref vdd sky130_fd_pr__pfet_01v8 w=8 l=0.15
X7ln bit7 b7bar 0 0 sky130_fd_pr__nfet_01v8 w=4 l=0.15
X7lp bit7 b7 0 vdd sky130_fd_pr__pfet_01v8 w=8 l=0.15
Rbranch7 n7 bit7 200000
Rterminate n7 0 200000
Rload n0 0 1000000
Cload n0 0 1e-13
.options reltol=1e-5 abstol=1e-14 vntol=1e-9
.control
set numdgt=15
alter VB0 = 0
alter VB0bar = 1.8
alter VB1 = 0
alter VB1bar = 1.8
alter VB2 = 0
alter VB2bar = 1.8
alter VB3 = 0
alter VB3bar = 1.8
alter VB4 = 0
alter VB4bar = 1.8
alter VB5 = 0
alter VB5bar = 1.8
alter VB6 = 0
alter VB6bar = 1.8
alter VB7 = 0
alter VB7bar = 1.8
op
echo REF_CODE_0
print v(n0) i(VREF) i(VDD)
alter VB0 = 0
alter VB0bar = 1.8
alter VB1 = 0
alter VB1bar = 1.8
alter VB2 = 0
alter VB2bar = 1.8
alter VB3 = 0
alter VB3bar = 1.8
alter VB4 = 0
alter VB4bar = 1.8
alter VB5 = 0
alter VB5bar = 1.8
alter VB6 = 0
alter VB6bar = 1.8
alter VB7 = 1.8
alter VB7bar = 0
op
echo REF_CODE_1
print v(n0) i(VREF) i(VDD)
alter VB0 = 0
alter VB0bar = 1.8
alter VB1 = 0
alter VB1bar = 1.8
alter VB2 = 0
alter VB2bar = 1.8
alter VB3 = 0
alter VB3bar = 1.8
alter VB4 = 0
alter VB4bar = 1.8
alter VB5 = 0
alter VB5bar = 1.8
alter VB6 = 1.8
alter VB6bar = 0
alter VB7 = 0
alter VB7bar = 1.8
op
echo REF_CODE_2
print v(n0) i(VREF) i(VDD)
alter VB0 = 0
alter VB0bar = 1.8
alter VB1 = 0
alter VB1bar = 1.8
alter VB2 = 0
alter VB2bar = 1.8
alter VB3 = 0
alter VB3bar = 1.8
alter VB4 = 0
alter VB4bar = 1.8
alter VB5 = 0
alter VB5bar = 1.8
alter VB6 = 1.8
alter VB6bar = 0
alter VB7 = 1.8
alter VB7bar = 0
op
echo REF_CODE_3
print v(n0) i(VREF) i(VDD)
alter VB0 = 0
alter VB0bar = 1.8
alter VB1 = 0
alter VB1bar = 1.8
alter VB2 = 0
alter VB2bar = 1.8
alter VB3 = 0
alter VB3bar = 1.8
alter VB4 = 0
alter VB4bar = 1.8
alter VB5 = 1.8
alter VB5bar = 0
alter VB6 = 0
alter VB6bar = 1.8
alter VB7 = 0
alter VB7bar = 1.8
op
echo REF_CODE_4
print v(n0) i(VREF) i(VDD)
alter VB0 = 0
alter VB0bar = 1.8
alter VB1 = 0
alter VB1bar = 1.8
alter VB2 = 0
alter VB2bar = 1.8
alter VB3 = 0
alter VB3bar = 1.8
alter VB4 = 0
alter VB4bar = 1.8
alter VB5 = 1.8
alter VB5bar = 0
alter VB6 = 0
alter VB6bar = 1.8
alter VB7 = 1.8
alter VB7bar = 0
op
echo REF_CODE_5
print v(n0) i(VREF) i(VDD)
alter VB0 = 0
alter VB0bar = 1.8
alter VB1 = 0
alter VB1bar = 1.8
alter VB2 = 0
alter VB2bar = 1.8
alter VB3 = 0
alter VB3bar = 1.8
alter VB4 = 0
alter VB4bar = 1.8
alter VB5 = 1.8
alter VB5bar = 0
alter VB6 = 1.8
alter VB6bar = 0
alter VB7 = 0
alter VB7bar = 1.8
op
echo REF_CODE_6
print v(n0) i(VREF) i(VDD)
alter VB0 = 0
alter VB0bar = 1.8
alter VB1 = 0
alter VB1bar = 1.8
alter VB2 = 0
alter VB2bar = 1.8
alter VB3 = 0
alter VB3bar = 1.8
alter VB4 = 0
alter VB4bar = 1.8
alter VB5 = 1.8
alter VB5bar = 0
alter VB6 = 1.8
alter VB6bar = 0
alter VB7 = 1.8
alter VB7bar = 0
op
echo REF_CODE_7
print v(n0) i(VREF) i(VDD)
alter VB0 = 0
alter VB0bar = 1.8
alter VB1 = 0
alter VB1bar = 1.8
alter VB2 = 0
alter VB2bar = 1.8
alter VB3 = 0
alter VB3bar = 1.8
alter VB4 = 1.8
alter VB4bar = 0
alter VB5 = 0
alter VB5bar = 1.8
alter VB6 = 0
alter VB6bar = 1.8
alter VB7 = 0
alter VB7bar = 1.8
op
echo REF_CODE_8
print v(n0) i(VREF) i(VDD)
alter VB0 = 0
alter VB0bar = 1.8
alter VB1 = 0
alter VB1bar = 1.8
alter VB2 = 0
alter VB2bar = 1.8
alter VB3 = 0
alter VB3bar = 1.8
alter VB4 = 1.8
alter VB4bar = 0
alter VB5 = 0
alter VB5bar = 1.8
alter VB6 = 0
alter VB6bar = 1.8
alter VB7 = 1.8
alter VB7bar = 0
op
echo REF_CODE_9
print v(n0) i(VREF) i(VDD)
alter VB0 = 0
alter VB0bar = 1.8
alter VB1 = 0
alter VB1bar = 1.8
alter VB2 = 0
alter VB2bar = 1.8
alter VB3 = 0
alter VB3bar = 1.8
alter VB4 = 1.8
alter VB4bar = 0
alter VB5 = 0
alter VB5bar = 1.8
alter VB6 = 1.8
alter VB6bar = 0
alter VB7 = 0
alter VB7bar = 1.8
op
echo REF_CODE_10
print v(n0) i(VREF) i(VDD)
alter VB0 = 0
alter VB0bar = 1.8
alter VB1 = 0
alter VB1bar = 1.8
alter VB2 = 0
alter VB2bar = 1.8
alter VB3 = 0
alter VB3bar = 1.8
alter VB4 = 1.8
alter VB4bar = 0
alter VB5 = 0
alter VB5bar = 1.8
alter VB6 = 1.8
alter VB6bar = 0
alter VB7 = 1.8
alter VB7bar = 0
op
echo REF_CODE_11
print v(n0) i(VREF) i(VDD)
alter VB0 = 0
alter VB0bar = 1.8
alter VB1 = 0
alter VB1bar = 1.8
alter VB2 = 0
alter VB2bar = 1.8
alter VB3 = 0
alter VB3bar = 1.8
alter VB4 = 1.8
alter VB4bar = 0
alter VB5 = 1.8
alter VB5bar = 0
alter VB6 = 0
alter VB6bar = 1.8
alter VB7 = 0
alter VB7bar = 1.8
op
echo REF_CODE_12
print v(n0) i(VREF) i(VDD)
alter VB0 = 0
alter VB0bar = 1.8
alter VB1 = 0
alter VB1bar = 1.8
alter VB2 = 0
alter VB2bar = 1.8
alter VB3 = 0
alter VB3bar = 1.8
alter VB4 = 1.8
alter VB4bar = 0
alter VB5 = 1.8
alter VB5bar = 0
alter VB6 = 0
alter VB6bar = 1.8
alter VB7 = 1.8
alter VB7bar = 0
op
echo REF_CODE_13
print v(n0) i(VREF) i(VDD)
alter VB0 = 0
alter VB0bar = 1.8
alter VB1 = 0
alter VB1bar = 1.8
alter VB2 = 0
alter VB2bar = 1.8
alter VB3 = 0
alter VB3bar = 1.8
alter VB4 = 1.8
alter VB4bar = 0
alter VB5 = 1.8
alter VB5bar = 0
alter VB6 = 1.8
alter VB6bar = 0
alter VB7 = 0
alter VB7bar = 1.8
op
echo REF_CODE_14
print v(n0) i(VREF) i(VDD)
alter VB0 = 0
alter VB0bar = 1.8
alter VB1 = 0
alter VB1bar = 1.8
alter VB2 = 0
alter VB2bar = 1.8
alter VB3 = 0
alter VB3bar = 1.8
alter VB4 = 1.8
alter VB4bar = 0
alter VB5 = 1.8
alter VB5bar = 0
alter VB6 = 1.8
alter VB6bar = 0
alter VB7 = 1.8
alter VB7bar = 0
op
echo REF_CODE_15
print v(n0) i(VREF) i(VDD)
alter VB0 = 0
alter VB0bar = 1.8
alter VB1 = 0
alter VB1bar = 1.8
alter VB2 = 0
alter VB2bar = 1.8
alter VB3 = 1.8
alter VB3bar = 0
alter VB4 = 0
alter VB4bar = 1.8
alter VB5 = 0
alter VB5bar = 1.8
alter VB6 = 0
alter VB6bar = 1.8
alter VB7 = 0
alter VB7bar = 1.8
op
echo REF_CODE_16
print v(n0) i(VREF) i(VDD)
alter VB0 = 0
alter VB0bar = 1.8
alter VB1 = 0
alter VB1bar = 1.8
alter VB2 = 0
alter VB2bar = 1.8
alter VB3 = 1.8
alter VB3bar = 0
alter VB4 = 0
alter VB4bar = 1.8
alter VB5 = 0
alter VB5bar = 1.8
alter VB6 = 0
alter VB6bar = 1.8
alter VB7 = 1.8
alter VB7bar = 0
op
echo REF_CODE_17
print v(n0) i(VREF) i(VDD)
alter VB0 = 0
alter VB0bar = 1.8
alter VB1 = 0
alter VB1bar = 1.8
alter VB2 = 0
alter VB2bar = 1.8
alter VB3 = 1.8
alter VB3bar = 0
alter VB4 = 0
alter VB4bar = 1.8
alter VB5 = 0
alter VB5bar = 1.8
alter VB6 = 1.8
alter VB6bar = 0
alter VB7 = 0
alter VB7bar = 1.8
op
echo REF_CODE_18
print v(n0) i(VREF) i(VDD)
alter VB0 = 0
alter VB0bar = 1.8
alter VB1 = 0
alter VB1bar = 1.8
alter VB2 = 0
alter VB2bar = 1.8
alter VB3 = 1.8
alter VB3bar = 0
alter VB4 = 0
alter VB4bar = 1.8
alter VB5 = 0
alter VB5bar = 1.8
alter VB6 = 1.8
alter VB6bar = 0
alter VB7 = 1.8
alter VB7bar = 0
op
echo REF_CODE_19
print v(n0) i(VREF) i(VDD)
alter VB0 = 0
alter VB0bar = 1.8
alter VB1 = 0
alter VB1bar = 1.8
alter VB2 = 0
alter VB2bar = 1.8
alter VB3 = 1.8
alter VB3bar = 0
alter VB4 = 0
alter VB4bar = 1.8
alter VB5 = 1.8
alter VB5bar = 0
alter VB6 = 0
alter VB6bar = 1.8
alter VB7 = 0
alter VB7bar = 1.8
op
echo REF_CODE_20
print v(n0) i(VREF) i(VDD)
alter VB0 = 0
alter VB0bar = 1.8
alter VB1 = 0
alter VB1bar = 1.8
alter VB2 = 0
alter VB2bar = 1.8
alter VB3 = 1.8
alter VB3bar = 0
alter VB4 = 0
alter VB4bar = 1.8
alter VB5 = 1.8
alter VB5bar = 0
alter VB6 = 0
alter VB6bar = 1.8
alter VB7 = 1.8
alter VB7bar = 0
op
echo REF_CODE_21
print v(n0) i(VREF) i(VDD)
alter VB0 = 0
alter VB0bar = 1.8
alter VB1 = 0
alter VB1bar = 1.8
alter VB2 = 0
alter VB2bar = 1.8
alter VB3 = 1.8
alter VB3bar = 0
alter VB4 = 0
alter VB4bar = 1.8
alter VB5 = 1.8
alter VB5bar = 0
alter VB6 = 1.8
alter VB6bar = 0
alter VB7 = 0
alter VB7bar = 1.8
op
echo REF_CODE_22
print v(n0) i(VREF) i(VDD)
alter VB0 = 0
alter VB0bar = 1.8
alter VB1 = 0
alter VB1bar = 1.8
alter VB2 = 0
alter VB2bar = 1.8
alter VB3 = 1.8
alter VB3bar = 0
alter VB4 = 0
alter VB4bar = 1.8
alter VB5 = 1.8
alter VB5bar = 0
alter VB6 = 1.8
alter VB6bar = 0
alter VB7 = 1.8
alter VB7bar = 0
op
echo REF_CODE_23
print v(n0) i(VREF) i(VDD)
alter VB0 = 0
alter VB0bar = 1.8
alter VB1 = 0
alter VB1bar = 1.8
alter VB2 = 0
alter VB2bar = 1.8
alter VB3 = 1.8
alter VB3bar = 0
alter VB4 = 1.8
alter VB4bar = 0
alter VB5 = 0
alter VB5bar = 1.8
alter VB6 = 0
alter VB6bar = 1.8
alter VB7 = 0
alter VB7bar = 1.8
op
echo REF_CODE_24
print v(n0) i(VREF) i(VDD)
alter VB0 = 0
alter VB0bar = 1.8
alter VB1 = 0
alter VB1bar = 1.8
alter VB2 = 0
alter VB2bar = 1.8
alter VB3 = 1.8
alter VB3bar = 0
alter VB4 = 1.8
alter VB4bar = 0
alter VB5 = 0
alter VB5bar = 1.8
alter VB6 = 0
alter VB6bar = 1.8
alter VB7 = 1.8
alter VB7bar = 0
op
echo REF_CODE_25
print v(n0) i(VREF) i(VDD)
alter VB0 = 0
alter VB0bar = 1.8
alter VB1 = 0
alter VB1bar = 1.8
alter VB2 = 0
alter VB2bar = 1.8
alter VB3 = 1.8
alter VB3bar = 0
alter VB4 = 1.8
alter VB4bar = 0
alter VB5 = 0
alter VB5bar = 1.8
alter VB6 = 1.8
alter VB6bar = 0
alter VB7 = 0
alter VB7bar = 1.8
op
echo REF_CODE_26
print v(n0) i(VREF) i(VDD)
alter VB0 = 0
alter VB0bar = 1.8
alter VB1 = 0
alter VB1bar = 1.8
alter VB2 = 0
alter VB2bar = 1.8
alter VB3 = 1.8
alter VB3bar = 0
alter VB4 = 1.8
alter VB4bar = 0
alter VB5 = 0
alter VB5bar = 1.8
alter VB6 = 1.8
alter VB6bar = 0
alter VB7 = 1.8
alter VB7bar = 0
op
echo REF_CODE_27
print v(n0) i(VREF) i(VDD)
alter VB0 = 0
alter VB0bar = 1.8
alter VB1 = 0
alter VB1bar = 1.8
alter VB2 = 0
alter VB2bar = 1.8
alter VB3 = 1.8
alter VB3bar = 0
alter VB4 = 1.8
alter VB4bar = 0
alter VB5 = 1.8
alter VB5bar = 0
alter VB6 = 0
alter VB6bar = 1.8
alter VB7 = 0
alter VB7bar = 1.8
op
echo REF_CODE_28
print v(n0) i(VREF) i(VDD)
alter VB0 = 0
alter VB0bar = 1.8
alter VB1 = 0
alter VB1bar = 1.8
alter VB2 = 0
alter VB2bar = 1.8
alter VB3 = 1.8
alter VB3bar = 0
alter VB4 = 1.8
alter VB4bar = 0
alter VB5 = 1.8
alter VB5bar = 0
alter VB6 = 0
alter VB6bar = 1.8
alter VB7 = 1.8
alter VB7bar = 0
op
echo REF_CODE_29
print v(n0) i(VREF) i(VDD)
alter VB0 = 0
alter VB0bar = 1.8
alter VB1 = 0
alter VB1bar = 1.8
alter VB2 = 0
alter VB2bar = 1.8
alter VB3 = 1.8
alter VB3bar = 0
alter VB4 = 1.8
alter VB4bar = 0
alter VB5 = 1.8
alter VB5bar = 0
alter VB6 = 1.8
alter VB6bar = 0
alter VB7 = 0
alter VB7bar = 1.8
op
echo REF_CODE_30
print v(n0) i(VREF) i(VDD)
alter VB0 = 0
alter VB0bar = 1.8
alter VB1 = 0
alter VB1bar = 1.8
alter VB2 = 0
alter VB2bar = 1.8
alter VB3 = 1.8
alter VB3bar = 0
alter VB4 = 1.8
alter VB4bar = 0
alter VB5 = 1.8
alter VB5bar = 0
alter VB6 = 1.8
alter VB6bar = 0
alter VB7 = 1.8
alter VB7bar = 0
op
echo REF_CODE_31
print v(n0) i(VREF) i(VDD)
alter VB0 = 0
alter VB0bar = 1.8
alter VB1 = 0
alter VB1bar = 1.8
alter VB2 = 1.8
alter VB2bar = 0
alter VB3 = 0
alter VB3bar = 1.8
alter VB4 = 0
alter VB4bar = 1.8
alter VB5 = 0
alter VB5bar = 1.8
alter VB6 = 0
alter VB6bar = 1.8
alter VB7 = 0
alter VB7bar = 1.8
op
echo REF_CODE_32
print v(n0) i(VREF) i(VDD)
alter VB0 = 0
alter VB0bar = 1.8
alter VB1 = 0
alter VB1bar = 1.8
alter VB2 = 1.8
alter VB2bar = 0
alter VB3 = 0
alter VB3bar = 1.8
alter VB4 = 0
alter VB4bar = 1.8
alter VB5 = 0
alter VB5bar = 1.8
alter VB6 = 0
alter VB6bar = 1.8
alter VB7 = 1.8
alter VB7bar = 0
op
echo REF_CODE_33
print v(n0) i(VREF) i(VDD)
alter VB0 = 0
alter VB0bar = 1.8
alter VB1 = 0
alter VB1bar = 1.8
alter VB2 = 1.8
alter VB2bar = 0
alter VB3 = 0
alter VB3bar = 1.8
alter VB4 = 0
alter VB4bar = 1.8
alter VB5 = 0
alter VB5bar = 1.8
alter VB6 = 1.8
alter VB6bar = 0
alter VB7 = 0
alter VB7bar = 1.8
op
echo REF_CODE_34
print v(n0) i(VREF) i(VDD)
alter VB0 = 0
alter VB0bar = 1.8
alter VB1 = 0
alter VB1bar = 1.8
alter VB2 = 1.8
alter VB2bar = 0
alter VB3 = 0
alter VB3bar = 1.8
alter VB4 = 0
alter VB4bar = 1.8
alter VB5 = 0
alter VB5bar = 1.8
alter VB6 = 1.8
alter VB6bar = 0
alter VB7 = 1.8
alter VB7bar = 0
op
echo REF_CODE_35
print v(n0) i(VREF) i(VDD)
alter VB0 = 0
alter VB0bar = 1.8
alter VB1 = 0
alter VB1bar = 1.8
alter VB2 = 1.8
alter VB2bar = 0
alter VB3 = 0
alter VB3bar = 1.8
alter VB4 = 0
alter VB4bar = 1.8
alter VB5 = 1.8
alter VB5bar = 0
alter VB6 = 0
alter VB6bar = 1.8
alter VB7 = 0
alter VB7bar = 1.8
op
echo REF_CODE_36
print v(n0) i(VREF) i(VDD)
alter VB0 = 0
alter VB0bar = 1.8
alter VB1 = 0
alter VB1bar = 1.8
alter VB2 = 1.8
alter VB2bar = 0
alter VB3 = 0
alter VB3bar = 1.8
alter VB4 = 0
alter VB4bar = 1.8
alter VB5 = 1.8
alter VB5bar = 0
alter VB6 = 0
alter VB6bar = 1.8
alter VB7 = 1.8
alter VB7bar = 0
op
echo REF_CODE_37
print v(n0) i(VREF) i(VDD)
alter VB0 = 0
alter VB0bar = 1.8
alter VB1 = 0
alter VB1bar = 1.8
alter VB2 = 1.8
alter VB2bar = 0
alter VB3 = 0
alter VB3bar = 1.8
alter VB4 = 0
alter VB4bar = 1.8
alter VB5 = 1.8
alter VB5bar = 0
alter VB6 = 1.8
alter VB6bar = 0
alter VB7 = 0
alter VB7bar = 1.8
op
echo REF_CODE_38
print v(n0) i(VREF) i(VDD)
alter VB0 = 0
alter VB0bar = 1.8
alter VB1 = 0
alter VB1bar = 1.8
alter VB2 = 1.8
alter VB2bar = 0
alter VB3 = 0
alter VB3bar = 1.8
alter VB4 = 0
alter VB4bar = 1.8
alter VB5 = 1.8
alter VB5bar = 0
alter VB6 = 1.8
alter VB6bar = 0
alter VB7 = 1.8
alter VB7bar = 0
op
echo REF_CODE_39
print v(n0) i(VREF) i(VDD)
alter VB0 = 0
alter VB0bar = 1.8
alter VB1 = 0
alter VB1bar = 1.8
alter VB2 = 1.8
alter VB2bar = 0
alter VB3 = 0
alter VB3bar = 1.8
alter VB4 = 1.8
alter VB4bar = 0
alter VB5 = 0
alter VB5bar = 1.8
alter VB6 = 0
alter VB6bar = 1.8
alter VB7 = 0
alter VB7bar = 1.8
op
echo REF_CODE_40
print v(n0) i(VREF) i(VDD)
alter VB0 = 0
alter VB0bar = 1.8
alter VB1 = 0
alter VB1bar = 1.8
alter VB2 = 1.8
alter VB2bar = 0
alter VB3 = 0
alter VB3bar = 1.8
alter VB4 = 1.8
alter VB4bar = 0
alter VB5 = 0
alter VB5bar = 1.8
alter VB6 = 0
alter VB6bar = 1.8
alter VB7 = 1.8
alter VB7bar = 0
op
echo REF_CODE_41
print v(n0) i(VREF) i(VDD)
alter VB0 = 0
alter VB0bar = 1.8
alter VB1 = 0
alter VB1bar = 1.8
alter VB2 = 1.8
alter VB2bar = 0
alter VB3 = 0
alter VB3bar = 1.8
alter VB4 = 1.8
alter VB4bar = 0
alter VB5 = 0
alter VB5bar = 1.8
alter VB6 = 1.8
alter VB6bar = 0
alter VB7 = 0
alter VB7bar = 1.8
op
echo REF_CODE_42
print v(n0) i(VREF) i(VDD)
alter VB0 = 0
alter VB0bar = 1.8
alter VB1 = 0
alter VB1bar = 1.8
alter VB2 = 1.8
alter VB2bar = 0
alter VB3 = 0
alter VB3bar = 1.8
alter VB4 = 1.8
alter VB4bar = 0
alter VB5 = 0
alter VB5bar = 1.8
alter VB6 = 1.8
alter VB6bar = 0
alter VB7 = 1.8
alter VB7bar = 0
op
echo REF_CODE_43
print v(n0) i(VREF) i(VDD)
alter VB0 = 0
alter VB0bar = 1.8
alter VB1 = 0
alter VB1bar = 1.8
alter VB2 = 1.8
alter VB2bar = 0
alter VB3 = 0
alter VB3bar = 1.8
alter VB4 = 1.8
alter VB4bar = 0
alter VB5 = 1.8
alter VB5bar = 0
alter VB6 = 0
alter VB6bar = 1.8
alter VB7 = 0
alter VB7bar = 1.8
op
echo REF_CODE_44
print v(n0) i(VREF) i(VDD)
alter VB0 = 0
alter VB0bar = 1.8
alter VB1 = 0
alter VB1bar = 1.8
alter VB2 = 1.8
alter VB2bar = 0
alter VB3 = 0
alter VB3bar = 1.8
alter VB4 = 1.8
alter VB4bar = 0
alter VB5 = 1.8
alter VB5bar = 0
alter VB6 = 0
alter VB6bar = 1.8
alter VB7 = 1.8
alter VB7bar = 0
op
echo REF_CODE_45
print v(n0) i(VREF) i(VDD)
alter VB0 = 0
alter VB0bar = 1.8
alter VB1 = 0
alter VB1bar = 1.8
alter VB2 = 1.8
alter VB2bar = 0
alter VB3 = 0
alter VB3bar = 1.8
alter VB4 = 1.8
alter VB4bar = 0
alter VB5 = 1.8
alter VB5bar = 0
alter VB6 = 1.8
alter VB6bar = 0
alter VB7 = 0
alter VB7bar = 1.8
op
echo REF_CODE_46
print v(n0) i(VREF) i(VDD)
alter VB0 = 0
alter VB0bar = 1.8
alter VB1 = 0
alter VB1bar = 1.8
alter VB2 = 1.8
alter VB2bar = 0
alter VB3 = 0
alter VB3bar = 1.8
alter VB4 = 1.8
alter VB4bar = 0
alter VB5 = 1.8
alter VB5bar = 0
alter VB6 = 1.8
alter VB6bar = 0
alter VB7 = 1.8
alter VB7bar = 0
op
echo REF_CODE_47
print v(n0) i(VREF) i(VDD)
alter VB0 = 0
alter VB0bar = 1.8
alter VB1 = 0
alter VB1bar = 1.8
alter VB2 = 1.8
alter VB2bar = 0
alter VB3 = 1.8
alter VB3bar = 0
alter VB4 = 0
alter VB4bar = 1.8
alter VB5 = 0
alter VB5bar = 1.8
alter VB6 = 0
alter VB6bar = 1.8
alter VB7 = 0
alter VB7bar = 1.8
op
echo REF_CODE_48
print v(n0) i(VREF) i(VDD)
alter VB0 = 0
alter VB0bar = 1.8
alter VB1 = 0
alter VB1bar = 1.8
alter VB2 = 1.8
alter VB2bar = 0
alter VB3 = 1.8
alter VB3bar = 0
alter VB4 = 0
alter VB4bar = 1.8
alter VB5 = 0
alter VB5bar = 1.8
alter VB6 = 0
alter VB6bar = 1.8
alter VB7 = 1.8
alter VB7bar = 0
op
echo REF_CODE_49
print v(n0) i(VREF) i(VDD)
alter VB0 = 0
alter VB0bar = 1.8
alter VB1 = 0
alter VB1bar = 1.8
alter VB2 = 1.8
alter VB2bar = 0
alter VB3 = 1.8
alter VB3bar = 0
alter VB4 = 0
alter VB4bar = 1.8
alter VB5 = 0
alter VB5bar = 1.8
alter VB6 = 1.8
alter VB6bar = 0
alter VB7 = 0
alter VB7bar = 1.8
op
echo REF_CODE_50
print v(n0) i(VREF) i(VDD)
alter VB0 = 0
alter VB0bar = 1.8
alter VB1 = 0
alter VB1bar = 1.8
alter VB2 = 1.8
alter VB2bar = 0
alter VB3 = 1.8
alter VB3bar = 0
alter VB4 = 0
alter VB4bar = 1.8
alter VB5 = 0
alter VB5bar = 1.8
alter VB6 = 1.8
alter VB6bar = 0
alter VB7 = 1.8
alter VB7bar = 0
op
echo REF_CODE_51
print v(n0) i(VREF) i(VDD)
alter VB0 = 0
alter VB0bar = 1.8
alter VB1 = 0
alter VB1bar = 1.8
alter VB2 = 1.8
alter VB2bar = 0
alter VB3 = 1.8
alter VB3bar = 0
alter VB4 = 0
alter VB4bar = 1.8
alter VB5 = 1.8
alter VB5bar = 0
alter VB6 = 0
alter VB6bar = 1.8
alter VB7 = 0
alter VB7bar = 1.8
op
echo REF_CODE_52
print v(n0) i(VREF) i(VDD)
alter VB0 = 0
alter VB0bar = 1.8
alter VB1 = 0
alter VB1bar = 1.8
alter VB2 = 1.8
alter VB2bar = 0
alter VB3 = 1.8
alter VB3bar = 0
alter VB4 = 0
alter VB4bar = 1.8
alter VB5 = 1.8
alter VB5bar = 0
alter VB6 = 0
alter VB6bar = 1.8
alter VB7 = 1.8
alter VB7bar = 0
op
echo REF_CODE_53
print v(n0) i(VREF) i(VDD)
alter VB0 = 0
alter VB0bar = 1.8
alter VB1 = 0
alter VB1bar = 1.8
alter VB2 = 1.8
alter VB2bar = 0
alter VB3 = 1.8
alter VB3bar = 0
alter VB4 = 0
alter VB4bar = 1.8
alter VB5 = 1.8
alter VB5bar = 0
alter VB6 = 1.8
alter VB6bar = 0
alter VB7 = 0
alter VB7bar = 1.8
op
echo REF_CODE_54
print v(n0) i(VREF) i(VDD)
alter VB0 = 0
alter VB0bar = 1.8
alter VB1 = 0
alter VB1bar = 1.8
alter VB2 = 1.8
alter VB2bar = 0
alter VB3 = 1.8
alter VB3bar = 0
alter VB4 = 0
alter VB4bar = 1.8
alter VB5 = 1.8
alter VB5bar = 0
alter VB6 = 1.8
alter VB6bar = 0
alter VB7 = 1.8
alter VB7bar = 0
op
echo REF_CODE_55
print v(n0) i(VREF) i(VDD)
alter VB0 = 0
alter VB0bar = 1.8
alter VB1 = 0
alter VB1bar = 1.8
alter VB2 = 1.8
alter VB2bar = 0
alter VB3 = 1.8
alter VB3bar = 0
alter VB4 = 1.8
alter VB4bar = 0
alter VB5 = 0
alter VB5bar = 1.8
alter VB6 = 0
alter VB6bar = 1.8
alter VB7 = 0
alter VB7bar = 1.8
op
echo REF_CODE_56
print v(n0) i(VREF) i(VDD)
alter VB0 = 0
alter VB0bar = 1.8
alter VB1 = 0
alter VB1bar = 1.8
alter VB2 = 1.8
alter VB2bar = 0
alter VB3 = 1.8
alter VB3bar = 0
alter VB4 = 1.8
alter VB4bar = 0
alter VB5 = 0
alter VB5bar = 1.8
alter VB6 = 0
alter VB6bar = 1.8
alter VB7 = 1.8
alter VB7bar = 0
op
echo REF_CODE_57
print v(n0) i(VREF) i(VDD)
alter VB0 = 0
alter VB0bar = 1.8
alter VB1 = 0
alter VB1bar = 1.8
alter VB2 = 1.8
alter VB2bar = 0
alter VB3 = 1.8
alter VB3bar = 0
alter VB4 = 1.8
alter VB4bar = 0
alter VB5 = 0
alter VB5bar = 1.8
alter VB6 = 1.8
alter VB6bar = 0
alter VB7 = 0
alter VB7bar = 1.8
op
echo REF_CODE_58
print v(n0) i(VREF) i(VDD)
alter VB0 = 0
alter VB0bar = 1.8
alter VB1 = 0
alter VB1bar = 1.8
alter VB2 = 1.8
alter VB2bar = 0
alter VB3 = 1.8
alter VB3bar = 0
alter VB4 = 1.8
alter VB4bar = 0
alter VB5 = 0
alter VB5bar = 1.8
alter VB6 = 1.8
alter VB6bar = 0
alter VB7 = 1.8
alter VB7bar = 0
op
echo REF_CODE_59
print v(n0) i(VREF) i(VDD)
alter VB0 = 0
alter VB0bar = 1.8
alter VB1 = 0
alter VB1bar = 1.8
alter VB2 = 1.8
alter VB2bar = 0
alter VB3 = 1.8
alter VB3bar = 0
alter VB4 = 1.8
alter VB4bar = 0
alter VB5 = 1.8
alter VB5bar = 0
alter VB6 = 0
alter VB6bar = 1.8
alter VB7 = 0
alter VB7bar = 1.8
op
echo REF_CODE_60
print v(n0) i(VREF) i(VDD)
alter VB0 = 0
alter VB0bar = 1.8
alter VB1 = 0
alter VB1bar = 1.8
alter VB2 = 1.8
alter VB2bar = 0
alter VB3 = 1.8
alter VB3bar = 0
alter VB4 = 1.8
alter VB4bar = 0
alter VB5 = 1.8
alter VB5bar = 0
alter VB6 = 0
alter VB6bar = 1.8
alter VB7 = 1.8
alter VB7bar = 0
op
echo REF_CODE_61
print v(n0) i(VREF) i(VDD)
alter VB0 = 0
alter VB0bar = 1.8
alter VB1 = 0
alter VB1bar = 1.8
alter VB2 = 1.8
alter VB2bar = 0
alter VB3 = 1.8
alter VB3bar = 0
alter VB4 = 1.8
alter VB4bar = 0
alter VB5 = 1.8
alter VB5bar = 0
alter VB6 = 1.8
alter VB6bar = 0
alter VB7 = 0
alter VB7bar = 1.8
op
echo REF_CODE_62
print v(n0) i(VREF) i(VDD)
alter VB0 = 0
alter VB0bar = 1.8
alter VB1 = 0
alter VB1bar = 1.8
alter VB2 = 1.8
alter VB2bar = 0
alter VB3 = 1.8
alter VB3bar = 0
alter VB4 = 1.8
alter VB4bar = 0
alter VB5 = 1.8
alter VB5bar = 0
alter VB6 = 1.8
alter VB6bar = 0
alter VB7 = 1.8
alter VB7bar = 0
op
echo REF_CODE_63
print v(n0) i(VREF) i(VDD)
alter VB0 = 0
alter VB0bar = 1.8
alter VB1 = 1.8
alter VB1bar = 0
alter VB2 = 0
alter VB2bar = 1.8
alter VB3 = 0
alter VB3bar = 1.8
alter VB4 = 0
alter VB4bar = 1.8
alter VB5 = 0
alter VB5bar = 1.8
alter VB6 = 0
alter VB6bar = 1.8
alter VB7 = 0
alter VB7bar = 1.8
op
echo REF_CODE_64
print v(n0) i(VREF) i(VDD)
alter VB0 = 0
alter VB0bar = 1.8
alter VB1 = 1.8
alter VB1bar = 0
alter VB2 = 0
alter VB2bar = 1.8
alter VB3 = 0
alter VB3bar = 1.8
alter VB4 = 0
alter VB4bar = 1.8
alter VB5 = 0
alter VB5bar = 1.8
alter VB6 = 0
alter VB6bar = 1.8
alter VB7 = 1.8
alter VB7bar = 0
op
echo REF_CODE_65
print v(n0) i(VREF) i(VDD)
alter VB0 = 0
alter VB0bar = 1.8
alter VB1 = 1.8
alter VB1bar = 0
alter VB2 = 0
alter VB2bar = 1.8
alter VB3 = 0
alter VB3bar = 1.8
alter VB4 = 0
alter VB4bar = 1.8
alter VB5 = 0
alter VB5bar = 1.8
alter VB6 = 1.8
alter VB6bar = 0
alter VB7 = 0
alter VB7bar = 1.8
op
echo REF_CODE_66
print v(n0) i(VREF) i(VDD)
alter VB0 = 0
alter VB0bar = 1.8
alter VB1 = 1.8
alter VB1bar = 0
alter VB2 = 0
alter VB2bar = 1.8
alter VB3 = 0
alter VB3bar = 1.8
alter VB4 = 0
alter VB4bar = 1.8
alter VB5 = 0
alter VB5bar = 1.8
alter VB6 = 1.8
alter VB6bar = 0
alter VB7 = 1.8
alter VB7bar = 0
op
echo REF_CODE_67
print v(n0) i(VREF) i(VDD)
alter VB0 = 0
alter VB0bar = 1.8
alter VB1 = 1.8
alter VB1bar = 0
alter VB2 = 0
alter VB2bar = 1.8
alter VB3 = 0
alter VB3bar = 1.8
alter VB4 = 0
alter VB4bar = 1.8
alter VB5 = 1.8
alter VB5bar = 0
alter VB6 = 0
alter VB6bar = 1.8
alter VB7 = 0
alter VB7bar = 1.8
op
echo REF_CODE_68
print v(n0) i(VREF) i(VDD)
alter VB0 = 0
alter VB0bar = 1.8
alter VB1 = 1.8
alter VB1bar = 0
alter VB2 = 0
alter VB2bar = 1.8
alter VB3 = 0
alter VB3bar = 1.8
alter VB4 = 0
alter VB4bar = 1.8
alter VB5 = 1.8
alter VB5bar = 0
alter VB6 = 0
alter VB6bar = 1.8
alter VB7 = 1.8
alter VB7bar = 0
op
echo REF_CODE_69
print v(n0) i(VREF) i(VDD)
alter VB0 = 0
alter VB0bar = 1.8
alter VB1 = 1.8
alter VB1bar = 0
alter VB2 = 0
alter VB2bar = 1.8
alter VB3 = 0
alter VB3bar = 1.8
alter VB4 = 0
alter VB4bar = 1.8
alter VB5 = 1.8
alter VB5bar = 0
alter VB6 = 1.8
alter VB6bar = 0
alter VB7 = 0
alter VB7bar = 1.8
op
echo REF_CODE_70
print v(n0) i(VREF) i(VDD)
alter VB0 = 0
alter VB0bar = 1.8
alter VB1 = 1.8
alter VB1bar = 0
alter VB2 = 0
alter VB2bar = 1.8
alter VB3 = 0
alter VB3bar = 1.8
alter VB4 = 0
alter VB4bar = 1.8
alter VB5 = 1.8
alter VB5bar = 0
alter VB6 = 1.8
alter VB6bar = 0
alter VB7 = 1.8
alter VB7bar = 0
op
echo REF_CODE_71
print v(n0) i(VREF) i(VDD)
alter VB0 = 0
alter VB0bar = 1.8
alter VB1 = 1.8
alter VB1bar = 0
alter VB2 = 0
alter VB2bar = 1.8
alter VB3 = 0
alter VB3bar = 1.8
alter VB4 = 1.8
alter VB4bar = 0
alter VB5 = 0
alter VB5bar = 1.8
alter VB6 = 0
alter VB6bar = 1.8
alter VB7 = 0
alter VB7bar = 1.8
op
echo REF_CODE_72
print v(n0) i(VREF) i(VDD)
alter VB0 = 0
alter VB0bar = 1.8
alter VB1 = 1.8
alter VB1bar = 0
alter VB2 = 0
alter VB2bar = 1.8
alter VB3 = 0
alter VB3bar = 1.8
alter VB4 = 1.8
alter VB4bar = 0
alter VB5 = 0
alter VB5bar = 1.8
alter VB6 = 0
alter VB6bar = 1.8
alter VB7 = 1.8
alter VB7bar = 0
op
echo REF_CODE_73
print v(n0) i(VREF) i(VDD)
alter VB0 = 0
alter VB0bar = 1.8
alter VB1 = 1.8
alter VB1bar = 0
alter VB2 = 0
alter VB2bar = 1.8
alter VB3 = 0
alter VB3bar = 1.8
alter VB4 = 1.8
alter VB4bar = 0
alter VB5 = 0
alter VB5bar = 1.8
alter VB6 = 1.8
alter VB6bar = 0
alter VB7 = 0
alter VB7bar = 1.8
op
echo REF_CODE_74
print v(n0) i(VREF) i(VDD)
alter VB0 = 0
alter VB0bar = 1.8
alter VB1 = 1.8
alter VB1bar = 0
alter VB2 = 0
alter VB2bar = 1.8
alter VB3 = 0
alter VB3bar = 1.8
alter VB4 = 1.8
alter VB4bar = 0
alter VB5 = 0
alter VB5bar = 1.8
alter VB6 = 1.8
alter VB6bar = 0
alter VB7 = 1.8
alter VB7bar = 0
op
echo REF_CODE_75
print v(n0) i(VREF) i(VDD)
alter VB0 = 0
alter VB0bar = 1.8
alter VB1 = 1.8
alter VB1bar = 0
alter VB2 = 0
alter VB2bar = 1.8
alter VB3 = 0
alter VB3bar = 1.8
alter VB4 = 1.8
alter VB4bar = 0
alter VB5 = 1.8
alter VB5bar = 0
alter VB6 = 0
alter VB6bar = 1.8
alter VB7 = 0
alter VB7bar = 1.8
op
echo REF_CODE_76
print v(n0) i(VREF) i(VDD)
alter VB0 = 0
alter VB0bar = 1.8
alter VB1 = 1.8
alter VB1bar = 0
alter VB2 = 0
alter VB2bar = 1.8
alter VB3 = 0
alter VB3bar = 1.8
alter VB4 = 1.8
alter VB4bar = 0
alter VB5 = 1.8
alter VB5bar = 0
alter VB6 = 0
alter VB6bar = 1.8
alter VB7 = 1.8
alter VB7bar = 0
op
echo REF_CODE_77
print v(n0) i(VREF) i(VDD)
alter VB0 = 0
alter VB0bar = 1.8
alter VB1 = 1.8
alter VB1bar = 0
alter VB2 = 0
alter VB2bar = 1.8
alter VB3 = 0
alter VB3bar = 1.8
alter VB4 = 1.8
alter VB4bar = 0
alter VB5 = 1.8
alter VB5bar = 0
alter VB6 = 1.8
alter VB6bar = 0
alter VB7 = 0
alter VB7bar = 1.8
op
echo REF_CODE_78
print v(n0) i(VREF) i(VDD)
alter VB0 = 0
alter VB0bar = 1.8
alter VB1 = 1.8
alter VB1bar = 0
alter VB2 = 0
alter VB2bar = 1.8
alter VB3 = 0
alter VB3bar = 1.8
alter VB4 = 1.8
alter VB4bar = 0
alter VB5 = 1.8
alter VB5bar = 0
alter VB6 = 1.8
alter VB6bar = 0
alter VB7 = 1.8
alter VB7bar = 0
op
echo REF_CODE_79
print v(n0) i(VREF) i(VDD)
alter VB0 = 0
alter VB0bar = 1.8
alter VB1 = 1.8
alter VB1bar = 0
alter VB2 = 0
alter VB2bar = 1.8
alter VB3 = 1.8
alter VB3bar = 0
alter VB4 = 0
alter VB4bar = 1.8
alter VB5 = 0
alter VB5bar = 1.8
alter VB6 = 0
alter VB6bar = 1.8
alter VB7 = 0
alter VB7bar = 1.8
op
echo REF_CODE_80
print v(n0) i(VREF) i(VDD)
alter VB0 = 0
alter VB0bar = 1.8
alter VB1 = 1.8
alter VB1bar = 0
alter VB2 = 0
alter VB2bar = 1.8
alter VB3 = 1.8
alter VB3bar = 0
alter VB4 = 0
alter VB4bar = 1.8
alter VB5 = 0
alter VB5bar = 1.8
alter VB6 = 0
alter VB6bar = 1.8
alter VB7 = 1.8
alter VB7bar = 0
op
echo REF_CODE_81
print v(n0) i(VREF) i(VDD)
alter VB0 = 0
alter VB0bar = 1.8
alter VB1 = 1.8
alter VB1bar = 0
alter VB2 = 0
alter VB2bar = 1.8
alter VB3 = 1.8
alter VB3bar = 0
alter VB4 = 0
alter VB4bar = 1.8
alter VB5 = 0
alter VB5bar = 1.8
alter VB6 = 1.8
alter VB6bar = 0
alter VB7 = 0
alter VB7bar = 1.8
op
echo REF_CODE_82
print v(n0) i(VREF) i(VDD)
alter VB0 = 0
alter VB0bar = 1.8
alter VB1 = 1.8
alter VB1bar = 0
alter VB2 = 0
alter VB2bar = 1.8
alter VB3 = 1.8
alter VB3bar = 0
alter VB4 = 0
alter VB4bar = 1.8
alter VB5 = 0
alter VB5bar = 1.8
alter VB6 = 1.8
alter VB6bar = 0
alter VB7 = 1.8
alter VB7bar = 0
op
echo REF_CODE_83
print v(n0) i(VREF) i(VDD)
alter VB0 = 0
alter VB0bar = 1.8
alter VB1 = 1.8
alter VB1bar = 0
alter VB2 = 0
alter VB2bar = 1.8
alter VB3 = 1.8
alter VB3bar = 0
alter VB4 = 0
alter VB4bar = 1.8
alter VB5 = 1.8
alter VB5bar = 0
alter VB6 = 0
alter VB6bar = 1.8
alter VB7 = 0
alter VB7bar = 1.8
op
echo REF_CODE_84
print v(n0) i(VREF) i(VDD)
alter VB0 = 0
alter VB0bar = 1.8
alter VB1 = 1.8
alter VB1bar = 0
alter VB2 = 0
alter VB2bar = 1.8
alter VB3 = 1.8
alter VB3bar = 0
alter VB4 = 0
alter VB4bar = 1.8
alter VB5 = 1.8
alter VB5bar = 0
alter VB6 = 0
alter VB6bar = 1.8
alter VB7 = 1.8
alter VB7bar = 0
op
echo REF_CODE_85
print v(n0) i(VREF) i(VDD)
alter VB0 = 0
alter VB0bar = 1.8
alter VB1 = 1.8
alter VB1bar = 0
alter VB2 = 0
alter VB2bar = 1.8
alter VB3 = 1.8
alter VB3bar = 0
alter VB4 = 0
alter VB4bar = 1.8
alter VB5 = 1.8
alter VB5bar = 0
alter VB6 = 1.8
alter VB6bar = 0
alter VB7 = 0
alter VB7bar = 1.8
op
echo REF_CODE_86
print v(n0) i(VREF) i(VDD)
alter VB0 = 0
alter VB0bar = 1.8
alter VB1 = 1.8
alter VB1bar = 0
alter VB2 = 0
alter VB2bar = 1.8
alter VB3 = 1.8
alter VB3bar = 0
alter VB4 = 0
alter VB4bar = 1.8
alter VB5 = 1.8
alter VB5bar = 0
alter VB6 = 1.8
alter VB6bar = 0
alter VB7 = 1.8
alter VB7bar = 0
op
echo REF_CODE_87
print v(n0) i(VREF) i(VDD)
alter VB0 = 0
alter VB0bar = 1.8
alter VB1 = 1.8
alter VB1bar = 0
alter VB2 = 0
alter VB2bar = 1.8
alter VB3 = 1.8
alter VB3bar = 0
alter VB4 = 1.8
alter VB4bar = 0
alter VB5 = 0
alter VB5bar = 1.8
alter VB6 = 0
alter VB6bar = 1.8
alter VB7 = 0
alter VB7bar = 1.8
op
echo REF_CODE_88
print v(n0) i(VREF) i(VDD)
alter VB0 = 0
alter VB0bar = 1.8
alter VB1 = 1.8
alter VB1bar = 0
alter VB2 = 0
alter VB2bar = 1.8
alter VB3 = 1.8
alter VB3bar = 0
alter VB4 = 1.8
alter VB4bar = 0
alter VB5 = 0
alter VB5bar = 1.8
alter VB6 = 0
alter VB6bar = 1.8
alter VB7 = 1.8
alter VB7bar = 0
op
echo REF_CODE_89
print v(n0) i(VREF) i(VDD)
alter VB0 = 0
alter VB0bar = 1.8
alter VB1 = 1.8
alter VB1bar = 0
alter VB2 = 0
alter VB2bar = 1.8
alter VB3 = 1.8
alter VB3bar = 0
alter VB4 = 1.8
alter VB4bar = 0
alter VB5 = 0
alter VB5bar = 1.8
alter VB6 = 1.8
alter VB6bar = 0
alter VB7 = 0
alter VB7bar = 1.8
op
echo REF_CODE_90
print v(n0) i(VREF) i(VDD)
alter VB0 = 0
alter VB0bar = 1.8
alter VB1 = 1.8
alter VB1bar = 0
alter VB2 = 0
alter VB2bar = 1.8
alter VB3 = 1.8
alter VB3bar = 0
alter VB4 = 1.8
alter VB4bar = 0
alter VB5 = 0
alter VB5bar = 1.8
alter VB6 = 1.8
alter VB6bar = 0
alter VB7 = 1.8
alter VB7bar = 0
op
echo REF_CODE_91
print v(n0) i(VREF) i(VDD)
alter VB0 = 0
alter VB0bar = 1.8
alter VB1 = 1.8
alter VB1bar = 0
alter VB2 = 0
alter VB2bar = 1.8
alter VB3 = 1.8
alter VB3bar = 0
alter VB4 = 1.8
alter VB4bar = 0
alter VB5 = 1.8
alter VB5bar = 0
alter VB6 = 0
alter VB6bar = 1.8
alter VB7 = 0
alter VB7bar = 1.8
op
echo REF_CODE_92
print v(n0) i(VREF) i(VDD)
alter VB0 = 0
alter VB0bar = 1.8
alter VB1 = 1.8
alter VB1bar = 0
alter VB2 = 0
alter VB2bar = 1.8
alter VB3 = 1.8
alter VB3bar = 0
alter VB4 = 1.8
alter VB4bar = 0
alter VB5 = 1.8
alter VB5bar = 0
alter VB6 = 0
alter VB6bar = 1.8
alter VB7 = 1.8
alter VB7bar = 0
op
echo REF_CODE_93
print v(n0) i(VREF) i(VDD)
alter VB0 = 0
alter VB0bar = 1.8
alter VB1 = 1.8
alter VB1bar = 0
alter VB2 = 0
alter VB2bar = 1.8
alter VB3 = 1.8
alter VB3bar = 0
alter VB4 = 1.8
alter VB4bar = 0
alter VB5 = 1.8
alter VB5bar = 0
alter VB6 = 1.8
alter VB6bar = 0
alter VB7 = 0
alter VB7bar = 1.8
op
echo REF_CODE_94
print v(n0) i(VREF) i(VDD)
alter VB0 = 0
alter VB0bar = 1.8
alter VB1 = 1.8
alter VB1bar = 0
alter VB2 = 0
alter VB2bar = 1.8
alter VB3 = 1.8
alter VB3bar = 0
alter VB4 = 1.8
alter VB4bar = 0
alter VB5 = 1.8
alter VB5bar = 0
alter VB6 = 1.8
alter VB6bar = 0
alter VB7 = 1.8
alter VB7bar = 0
op
echo REF_CODE_95
print v(n0) i(VREF) i(VDD)
alter VB0 = 0
alter VB0bar = 1.8
alter VB1 = 1.8
alter VB1bar = 0
alter VB2 = 1.8
alter VB2bar = 0
alter VB3 = 0
alter VB3bar = 1.8
alter VB4 = 0
alter VB4bar = 1.8
alter VB5 = 0
alter VB5bar = 1.8
alter VB6 = 0
alter VB6bar = 1.8
alter VB7 = 0
alter VB7bar = 1.8
op
echo REF_CODE_96
print v(n0) i(VREF) i(VDD)
alter VB0 = 0
alter VB0bar = 1.8
alter VB1 = 1.8
alter VB1bar = 0
alter VB2 = 1.8
alter VB2bar = 0
alter VB3 = 0
alter VB3bar = 1.8
alter VB4 = 0
alter VB4bar = 1.8
alter VB5 = 0
alter VB5bar = 1.8
alter VB6 = 0
alter VB6bar = 1.8
alter VB7 = 1.8
alter VB7bar = 0
op
echo REF_CODE_97
print v(n0) i(VREF) i(VDD)
alter VB0 = 0
alter VB0bar = 1.8
alter VB1 = 1.8
alter VB1bar = 0
alter VB2 = 1.8
alter VB2bar = 0
alter VB3 = 0
alter VB3bar = 1.8
alter VB4 = 0
alter VB4bar = 1.8
alter VB5 = 0
alter VB5bar = 1.8
alter VB6 = 1.8
alter VB6bar = 0
alter VB7 = 0
alter VB7bar = 1.8
op
echo REF_CODE_98
print v(n0) i(VREF) i(VDD)
alter VB0 = 0
alter VB0bar = 1.8
alter VB1 = 1.8
alter VB1bar = 0
alter VB2 = 1.8
alter VB2bar = 0
alter VB3 = 0
alter VB3bar = 1.8
alter VB4 = 0
alter VB4bar = 1.8
alter VB5 = 0
alter VB5bar = 1.8
alter VB6 = 1.8
alter VB6bar = 0
alter VB7 = 1.8
alter VB7bar = 0
op
echo REF_CODE_99
print v(n0) i(VREF) i(VDD)
alter VB0 = 0
alter VB0bar = 1.8
alter VB1 = 1.8
alter VB1bar = 0
alter VB2 = 1.8
alter VB2bar = 0
alter VB3 = 0
alter VB3bar = 1.8
alter VB4 = 0
alter VB4bar = 1.8
alter VB5 = 1.8
alter VB5bar = 0
alter VB6 = 0
alter VB6bar = 1.8
alter VB7 = 0
alter VB7bar = 1.8
op
echo REF_CODE_100
print v(n0) i(VREF) i(VDD)
alter VB0 = 0
alter VB0bar = 1.8
alter VB1 = 1.8
alter VB1bar = 0
alter VB2 = 1.8
alter VB2bar = 0
alter VB3 = 0
alter VB3bar = 1.8
alter VB4 = 0
alter VB4bar = 1.8
alter VB5 = 1.8
alter VB5bar = 0
alter VB6 = 0
alter VB6bar = 1.8
alter VB7 = 1.8
alter VB7bar = 0
op
echo REF_CODE_101
print v(n0) i(VREF) i(VDD)
alter VB0 = 0
alter VB0bar = 1.8
alter VB1 = 1.8
alter VB1bar = 0
alter VB2 = 1.8
alter VB2bar = 0
alter VB3 = 0
alter VB3bar = 1.8
alter VB4 = 0
alter VB4bar = 1.8
alter VB5 = 1.8
alter VB5bar = 0
alter VB6 = 1.8
alter VB6bar = 0
alter VB7 = 0
alter VB7bar = 1.8
op
echo REF_CODE_102
print v(n0) i(VREF) i(VDD)
alter VB0 = 0
alter VB0bar = 1.8
alter VB1 = 1.8
alter VB1bar = 0
alter VB2 = 1.8
alter VB2bar = 0
alter VB3 = 0
alter VB3bar = 1.8
alter VB4 = 0
alter VB4bar = 1.8
alter VB5 = 1.8
alter VB5bar = 0
alter VB6 = 1.8
alter VB6bar = 0
alter VB7 = 1.8
alter VB7bar = 0
op
echo REF_CODE_103
print v(n0) i(VREF) i(VDD)
alter VB0 = 0
alter VB0bar = 1.8
alter VB1 = 1.8
alter VB1bar = 0
alter VB2 = 1.8
alter VB2bar = 0
alter VB3 = 0
alter VB3bar = 1.8
alter VB4 = 1.8
alter VB4bar = 0
alter VB5 = 0
alter VB5bar = 1.8
alter VB6 = 0
alter VB6bar = 1.8
alter VB7 = 0
alter VB7bar = 1.8
op
echo REF_CODE_104
print v(n0) i(VREF) i(VDD)
alter VB0 = 0
alter VB0bar = 1.8
alter VB1 = 1.8
alter VB1bar = 0
alter VB2 = 1.8
alter VB2bar = 0
alter VB3 = 0
alter VB3bar = 1.8
alter VB4 = 1.8
alter VB4bar = 0
alter VB5 = 0
alter VB5bar = 1.8
alter VB6 = 0
alter VB6bar = 1.8
alter VB7 = 1.8
alter VB7bar = 0
op
echo REF_CODE_105
print v(n0) i(VREF) i(VDD)
alter VB0 = 0
alter VB0bar = 1.8
alter VB1 = 1.8
alter VB1bar = 0
alter VB2 = 1.8
alter VB2bar = 0
alter VB3 = 0
alter VB3bar = 1.8
alter VB4 = 1.8
alter VB4bar = 0
alter VB5 = 0
alter VB5bar = 1.8
alter VB6 = 1.8
alter VB6bar = 0
alter VB7 = 0
alter VB7bar = 1.8
op
echo REF_CODE_106
print v(n0) i(VREF) i(VDD)
alter VB0 = 0
alter VB0bar = 1.8
alter VB1 = 1.8
alter VB1bar = 0
alter VB2 = 1.8
alter VB2bar = 0
alter VB3 = 0
alter VB3bar = 1.8
alter VB4 = 1.8
alter VB4bar = 0
alter VB5 = 0
alter VB5bar = 1.8
alter VB6 = 1.8
alter VB6bar = 0
alter VB7 = 1.8
alter VB7bar = 0
op
echo REF_CODE_107
print v(n0) i(VREF) i(VDD)
alter VB0 = 0
alter VB0bar = 1.8
alter VB1 = 1.8
alter VB1bar = 0
alter VB2 = 1.8
alter VB2bar = 0
alter VB3 = 0
alter VB3bar = 1.8
alter VB4 = 1.8
alter VB4bar = 0
alter VB5 = 1.8
alter VB5bar = 0
alter VB6 = 0
alter VB6bar = 1.8
alter VB7 = 0
alter VB7bar = 1.8
op
echo REF_CODE_108
print v(n0) i(VREF) i(VDD)
alter VB0 = 0
alter VB0bar = 1.8
alter VB1 = 1.8
alter VB1bar = 0
alter VB2 = 1.8
alter VB2bar = 0
alter VB3 = 0
alter VB3bar = 1.8
alter VB4 = 1.8
alter VB4bar = 0
alter VB5 = 1.8
alter VB5bar = 0
alter VB6 = 0
alter VB6bar = 1.8
alter VB7 = 1.8
alter VB7bar = 0
op
echo REF_CODE_109
print v(n0) i(VREF) i(VDD)
alter VB0 = 0
alter VB0bar = 1.8
alter VB1 = 1.8
alter VB1bar = 0
alter VB2 = 1.8
alter VB2bar = 0
alter VB3 = 0
alter VB3bar = 1.8
alter VB4 = 1.8
alter VB4bar = 0
alter VB5 = 1.8
alter VB5bar = 0
alter VB6 = 1.8
alter VB6bar = 0
alter VB7 = 0
alter VB7bar = 1.8
op
echo REF_CODE_110
print v(n0) i(VREF) i(VDD)
alter VB0 = 0
alter VB0bar = 1.8
alter VB1 = 1.8
alter VB1bar = 0
alter VB2 = 1.8
alter VB2bar = 0
alter VB3 = 0
alter VB3bar = 1.8
alter VB4 = 1.8
alter VB4bar = 0
alter VB5 = 1.8
alter VB5bar = 0
alter VB6 = 1.8
alter VB6bar = 0
alter VB7 = 1.8
alter VB7bar = 0
op
echo REF_CODE_111
print v(n0) i(VREF) i(VDD)
alter VB0 = 0
alter VB0bar = 1.8
alter VB1 = 1.8
alter VB1bar = 0
alter VB2 = 1.8
alter VB2bar = 0
alter VB3 = 1.8
alter VB3bar = 0
alter VB4 = 0
alter VB4bar = 1.8
alter VB5 = 0
alter VB5bar = 1.8
alter VB6 = 0
alter VB6bar = 1.8
alter VB7 = 0
alter VB7bar = 1.8
op
echo REF_CODE_112
print v(n0) i(VREF) i(VDD)
alter VB0 = 0
alter VB0bar = 1.8
alter VB1 = 1.8
alter VB1bar = 0
alter VB2 = 1.8
alter VB2bar = 0
alter VB3 = 1.8
alter VB3bar = 0
alter VB4 = 0
alter VB4bar = 1.8
alter VB5 = 0
alter VB5bar = 1.8
alter VB6 = 0
alter VB6bar = 1.8
alter VB7 = 1.8
alter VB7bar = 0
op
echo REF_CODE_113
print v(n0) i(VREF) i(VDD)
alter VB0 = 0
alter VB0bar = 1.8
alter VB1 = 1.8
alter VB1bar = 0
alter VB2 = 1.8
alter VB2bar = 0
alter VB3 = 1.8
alter VB3bar = 0
alter VB4 = 0
alter VB4bar = 1.8
alter VB5 = 0
alter VB5bar = 1.8
alter VB6 = 1.8
alter VB6bar = 0
alter VB7 = 0
alter VB7bar = 1.8
op
echo REF_CODE_114
print v(n0) i(VREF) i(VDD)
alter VB0 = 0
alter VB0bar = 1.8
alter VB1 = 1.8
alter VB1bar = 0
alter VB2 = 1.8
alter VB2bar = 0
alter VB3 = 1.8
alter VB3bar = 0
alter VB4 = 0
alter VB4bar = 1.8
alter VB5 = 0
alter VB5bar = 1.8
alter VB6 = 1.8
alter VB6bar = 0
alter VB7 = 1.8
alter VB7bar = 0
op
echo REF_CODE_115
print v(n0) i(VREF) i(VDD)
alter VB0 = 0
alter VB0bar = 1.8
alter VB1 = 1.8
alter VB1bar = 0
alter VB2 = 1.8
alter VB2bar = 0
alter VB3 = 1.8
alter VB3bar = 0
alter VB4 = 0
alter VB4bar = 1.8
alter VB5 = 1.8
alter VB5bar = 0
alter VB6 = 0
alter VB6bar = 1.8
alter VB7 = 0
alter VB7bar = 1.8
op
echo REF_CODE_116
print v(n0) i(VREF) i(VDD)
alter VB0 = 0
alter VB0bar = 1.8
alter VB1 = 1.8
alter VB1bar = 0
alter VB2 = 1.8
alter VB2bar = 0
alter VB3 = 1.8
alter VB3bar = 0
alter VB4 = 0
alter VB4bar = 1.8
alter VB5 = 1.8
alter VB5bar = 0
alter VB6 = 0
alter VB6bar = 1.8
alter VB7 = 1.8
alter VB7bar = 0
op
echo REF_CODE_117
print v(n0) i(VREF) i(VDD)
alter VB0 = 0
alter VB0bar = 1.8
alter VB1 = 1.8
alter VB1bar = 0
alter VB2 = 1.8
alter VB2bar = 0
alter VB3 = 1.8
alter VB3bar = 0
alter VB4 = 0
alter VB4bar = 1.8
alter VB5 = 1.8
alter VB5bar = 0
alter VB6 = 1.8
alter VB6bar = 0
alter VB7 = 0
alter VB7bar = 1.8
op
echo REF_CODE_118
print v(n0) i(VREF) i(VDD)
alter VB0 = 0
alter VB0bar = 1.8
alter VB1 = 1.8
alter VB1bar = 0
alter VB2 = 1.8
alter VB2bar = 0
alter VB3 = 1.8
alter VB3bar = 0
alter VB4 = 0
alter VB4bar = 1.8
alter VB5 = 1.8
alter VB5bar = 0
alter VB6 = 1.8
alter VB6bar = 0
alter VB7 = 1.8
alter VB7bar = 0
op
echo REF_CODE_119
print v(n0) i(VREF) i(VDD)
alter VB0 = 0
alter VB0bar = 1.8
alter VB1 = 1.8
alter VB1bar = 0
alter VB2 = 1.8
alter VB2bar = 0
alter VB3 = 1.8
alter VB3bar = 0
alter VB4 = 1.8
alter VB4bar = 0
alter VB5 = 0
alter VB5bar = 1.8
alter VB6 = 0
alter VB6bar = 1.8
alter VB7 = 0
alter VB7bar = 1.8
op
echo REF_CODE_120
print v(n0) i(VREF) i(VDD)
alter VB0 = 0
alter VB0bar = 1.8
alter VB1 = 1.8
alter VB1bar = 0
alter VB2 = 1.8
alter VB2bar = 0
alter VB3 = 1.8
alter VB3bar = 0
alter VB4 = 1.8
alter VB4bar = 0
alter VB5 = 0
alter VB5bar = 1.8
alter VB6 = 0
alter VB6bar = 1.8
alter VB7 = 1.8
alter VB7bar = 0
op
echo REF_CODE_121
print v(n0) i(VREF) i(VDD)
alter VB0 = 0
alter VB0bar = 1.8
alter VB1 = 1.8
alter VB1bar = 0
alter VB2 = 1.8
alter VB2bar = 0
alter VB3 = 1.8
alter VB3bar = 0
alter VB4 = 1.8
alter VB4bar = 0
alter VB5 = 0
alter VB5bar = 1.8
alter VB6 = 1.8
alter VB6bar = 0
alter VB7 = 0
alter VB7bar = 1.8
op
echo REF_CODE_122
print v(n0) i(VREF) i(VDD)
alter VB0 = 0
alter VB0bar = 1.8
alter VB1 = 1.8
alter VB1bar = 0
alter VB2 = 1.8
alter VB2bar = 0
alter VB3 = 1.8
alter VB3bar = 0
alter VB4 = 1.8
alter VB4bar = 0
alter VB5 = 0
alter VB5bar = 1.8
alter VB6 = 1.8
alter VB6bar = 0
alter VB7 = 1.8
alter VB7bar = 0
op
echo REF_CODE_123
print v(n0) i(VREF) i(VDD)
alter VB0 = 0
alter VB0bar = 1.8
alter VB1 = 1.8
alter VB1bar = 0
alter VB2 = 1.8
alter VB2bar = 0
alter VB3 = 1.8
alter VB3bar = 0
alter VB4 = 1.8
alter VB4bar = 0
alter VB5 = 1.8
alter VB5bar = 0
alter VB6 = 0
alter VB6bar = 1.8
alter VB7 = 0
alter VB7bar = 1.8
op
echo REF_CODE_124
print v(n0) i(VREF) i(VDD)
alter VB0 = 0
alter VB0bar = 1.8
alter VB1 = 1.8
alter VB1bar = 0
alter VB2 = 1.8
alter VB2bar = 0
alter VB3 = 1.8
alter VB3bar = 0
alter VB4 = 1.8
alter VB4bar = 0
alter VB5 = 1.8
alter VB5bar = 0
alter VB6 = 0
alter VB6bar = 1.8
alter VB7 = 1.8
alter VB7bar = 0
op
echo REF_CODE_125
print v(n0) i(VREF) i(VDD)
alter VB0 = 0
alter VB0bar = 1.8
alter VB1 = 1.8
alter VB1bar = 0
alter VB2 = 1.8
alter VB2bar = 0
alter VB3 = 1.8
alter VB3bar = 0
alter VB4 = 1.8
alter VB4bar = 0
alter VB5 = 1.8
alter VB5bar = 0
alter VB6 = 1.8
alter VB6bar = 0
alter VB7 = 0
alter VB7bar = 1.8
op
echo REF_CODE_126
print v(n0) i(VREF) i(VDD)
alter VB0 = 0
alter VB0bar = 1.8
alter VB1 = 1.8
alter VB1bar = 0
alter VB2 = 1.8
alter VB2bar = 0
alter VB3 = 1.8
alter VB3bar = 0
alter VB4 = 1.8
alter VB4bar = 0
alter VB5 = 1.8
alter VB5bar = 0
alter VB6 = 1.8
alter VB6bar = 0
alter VB7 = 1.8
alter VB7bar = 0
op
echo REF_CODE_127
print v(n0) i(VREF) i(VDD)
alter VB0 = 1.8
alter VB0bar = 0
alter VB1 = 0
alter VB1bar = 1.8
alter VB2 = 0
alter VB2bar = 1.8
alter VB3 = 0
alter VB3bar = 1.8
alter VB4 = 0
alter VB4bar = 1.8
alter VB5 = 0
alter VB5bar = 1.8
alter VB6 = 0
alter VB6bar = 1.8
alter VB7 = 0
alter VB7bar = 1.8
op
echo REF_CODE_128
print v(n0) i(VREF) i(VDD)
alter VB0 = 1.8
alter VB0bar = 0
alter VB1 = 0
alter VB1bar = 1.8
alter VB2 = 0
alter VB2bar = 1.8
alter VB3 = 0
alter VB3bar = 1.8
alter VB4 = 0
alter VB4bar = 1.8
alter VB5 = 0
alter VB5bar = 1.8
alter VB6 = 0
alter VB6bar = 1.8
alter VB7 = 1.8
alter VB7bar = 0
op
echo REF_CODE_129
print v(n0) i(VREF) i(VDD)
alter VB0 = 1.8
alter VB0bar = 0
alter VB1 = 0
alter VB1bar = 1.8
alter VB2 = 0
alter VB2bar = 1.8
alter VB3 = 0
alter VB3bar = 1.8
alter VB4 = 0
alter VB4bar = 1.8
alter VB5 = 0
alter VB5bar = 1.8
alter VB6 = 1.8
alter VB6bar = 0
alter VB7 = 0
alter VB7bar = 1.8
op
echo REF_CODE_130
print v(n0) i(VREF) i(VDD)
alter VB0 = 1.8
alter VB0bar = 0
alter VB1 = 0
alter VB1bar = 1.8
alter VB2 = 0
alter VB2bar = 1.8
alter VB3 = 0
alter VB3bar = 1.8
alter VB4 = 0
alter VB4bar = 1.8
alter VB5 = 0
alter VB5bar = 1.8
alter VB6 = 1.8
alter VB6bar = 0
alter VB7 = 1.8
alter VB7bar = 0
op
echo REF_CODE_131
print v(n0) i(VREF) i(VDD)
alter VB0 = 1.8
alter VB0bar = 0
alter VB1 = 0
alter VB1bar = 1.8
alter VB2 = 0
alter VB2bar = 1.8
alter VB3 = 0
alter VB3bar = 1.8
alter VB4 = 0
alter VB4bar = 1.8
alter VB5 = 1.8
alter VB5bar = 0
alter VB6 = 0
alter VB6bar = 1.8
alter VB7 = 0
alter VB7bar = 1.8
op
echo REF_CODE_132
print v(n0) i(VREF) i(VDD)
alter VB0 = 1.8
alter VB0bar = 0
alter VB1 = 0
alter VB1bar = 1.8
alter VB2 = 0
alter VB2bar = 1.8
alter VB3 = 0
alter VB3bar = 1.8
alter VB4 = 0
alter VB4bar = 1.8
alter VB5 = 1.8
alter VB5bar = 0
alter VB6 = 0
alter VB6bar = 1.8
alter VB7 = 1.8
alter VB7bar = 0
op
echo REF_CODE_133
print v(n0) i(VREF) i(VDD)
alter VB0 = 1.8
alter VB0bar = 0
alter VB1 = 0
alter VB1bar = 1.8
alter VB2 = 0
alter VB2bar = 1.8
alter VB3 = 0
alter VB3bar = 1.8
alter VB4 = 0
alter VB4bar = 1.8
alter VB5 = 1.8
alter VB5bar = 0
alter VB6 = 1.8
alter VB6bar = 0
alter VB7 = 0
alter VB7bar = 1.8
op
echo REF_CODE_134
print v(n0) i(VREF) i(VDD)
alter VB0 = 1.8
alter VB0bar = 0
alter VB1 = 0
alter VB1bar = 1.8
alter VB2 = 0
alter VB2bar = 1.8
alter VB3 = 0
alter VB3bar = 1.8
alter VB4 = 0
alter VB4bar = 1.8
alter VB5 = 1.8
alter VB5bar = 0
alter VB6 = 1.8
alter VB6bar = 0
alter VB7 = 1.8
alter VB7bar = 0
op
echo REF_CODE_135
print v(n0) i(VREF) i(VDD)
alter VB0 = 1.8
alter VB0bar = 0
alter VB1 = 0
alter VB1bar = 1.8
alter VB2 = 0
alter VB2bar = 1.8
alter VB3 = 0
alter VB3bar = 1.8
alter VB4 = 1.8
alter VB4bar = 0
alter VB5 = 0
alter VB5bar = 1.8
alter VB6 = 0
alter VB6bar = 1.8
alter VB7 = 0
alter VB7bar = 1.8
op
echo REF_CODE_136
print v(n0) i(VREF) i(VDD)
alter VB0 = 1.8
alter VB0bar = 0
alter VB1 = 0
alter VB1bar = 1.8
alter VB2 = 0
alter VB2bar = 1.8
alter VB3 = 0
alter VB3bar = 1.8
alter VB4 = 1.8
alter VB4bar = 0
alter VB5 = 0
alter VB5bar = 1.8
alter VB6 = 0
alter VB6bar = 1.8
alter VB7 = 1.8
alter VB7bar = 0
op
echo REF_CODE_137
print v(n0) i(VREF) i(VDD)
alter VB0 = 1.8
alter VB0bar = 0
alter VB1 = 0
alter VB1bar = 1.8
alter VB2 = 0
alter VB2bar = 1.8
alter VB3 = 0
alter VB3bar = 1.8
alter VB4 = 1.8
alter VB4bar = 0
alter VB5 = 0
alter VB5bar = 1.8
alter VB6 = 1.8
alter VB6bar = 0
alter VB7 = 0
alter VB7bar = 1.8
op
echo REF_CODE_138
print v(n0) i(VREF) i(VDD)
alter VB0 = 1.8
alter VB0bar = 0
alter VB1 = 0
alter VB1bar = 1.8
alter VB2 = 0
alter VB2bar = 1.8
alter VB3 = 0
alter VB3bar = 1.8
alter VB4 = 1.8
alter VB4bar = 0
alter VB5 = 0
alter VB5bar = 1.8
alter VB6 = 1.8
alter VB6bar = 0
alter VB7 = 1.8
alter VB7bar = 0
op
echo REF_CODE_139
print v(n0) i(VREF) i(VDD)
alter VB0 = 1.8
alter VB0bar = 0
alter VB1 = 0
alter VB1bar = 1.8
alter VB2 = 0
alter VB2bar = 1.8
alter VB3 = 0
alter VB3bar = 1.8
alter VB4 = 1.8
alter VB4bar = 0
alter VB5 = 1.8
alter VB5bar = 0
alter VB6 = 0
alter VB6bar = 1.8
alter VB7 = 0
alter VB7bar = 1.8
op
echo REF_CODE_140
print v(n0) i(VREF) i(VDD)
alter VB0 = 1.8
alter VB0bar = 0
alter VB1 = 0
alter VB1bar = 1.8
alter VB2 = 0
alter VB2bar = 1.8
alter VB3 = 0
alter VB3bar = 1.8
alter VB4 = 1.8
alter VB4bar = 0
alter VB5 = 1.8
alter VB5bar = 0
alter VB6 = 0
alter VB6bar = 1.8
alter VB7 = 1.8
alter VB7bar = 0
op
echo REF_CODE_141
print v(n0) i(VREF) i(VDD)
alter VB0 = 1.8
alter VB0bar = 0
alter VB1 = 0
alter VB1bar = 1.8
alter VB2 = 0
alter VB2bar = 1.8
alter VB3 = 0
alter VB3bar = 1.8
alter VB4 = 1.8
alter VB4bar = 0
alter VB5 = 1.8
alter VB5bar = 0
alter VB6 = 1.8
alter VB6bar = 0
alter VB7 = 0
alter VB7bar = 1.8
op
echo REF_CODE_142
print v(n0) i(VREF) i(VDD)
alter VB0 = 1.8
alter VB0bar = 0
alter VB1 = 0
alter VB1bar = 1.8
alter VB2 = 0
alter VB2bar = 1.8
alter VB3 = 0
alter VB3bar = 1.8
alter VB4 = 1.8
alter VB4bar = 0
alter VB5 = 1.8
alter VB5bar = 0
alter VB6 = 1.8
alter VB6bar = 0
alter VB7 = 1.8
alter VB7bar = 0
op
echo REF_CODE_143
print v(n0) i(VREF) i(VDD)
alter VB0 = 1.8
alter VB0bar = 0
alter VB1 = 0
alter VB1bar = 1.8
alter VB2 = 0
alter VB2bar = 1.8
alter VB3 = 1.8
alter VB3bar = 0
alter VB4 = 0
alter VB4bar = 1.8
alter VB5 = 0
alter VB5bar = 1.8
alter VB6 = 0
alter VB6bar = 1.8
alter VB7 = 0
alter VB7bar = 1.8
op
echo REF_CODE_144
print v(n0) i(VREF) i(VDD)
alter VB0 = 1.8
alter VB0bar = 0
alter VB1 = 0
alter VB1bar = 1.8
alter VB2 = 0
alter VB2bar = 1.8
alter VB3 = 1.8
alter VB3bar = 0
alter VB4 = 0
alter VB4bar = 1.8
alter VB5 = 0
alter VB5bar = 1.8
alter VB6 = 0
alter VB6bar = 1.8
alter VB7 = 1.8
alter VB7bar = 0
op
echo REF_CODE_145
print v(n0) i(VREF) i(VDD)
alter VB0 = 1.8
alter VB0bar = 0
alter VB1 = 0
alter VB1bar = 1.8
alter VB2 = 0
alter VB2bar = 1.8
alter VB3 = 1.8
alter VB3bar = 0
alter VB4 = 0
alter VB4bar = 1.8
alter VB5 = 0
alter VB5bar = 1.8
alter VB6 = 1.8
alter VB6bar = 0
alter VB7 = 0
alter VB7bar = 1.8
op
echo REF_CODE_146
print v(n0) i(VREF) i(VDD)
alter VB0 = 1.8
alter VB0bar = 0
alter VB1 = 0
alter VB1bar = 1.8
alter VB2 = 0
alter VB2bar = 1.8
alter VB3 = 1.8
alter VB3bar = 0
alter VB4 = 0
alter VB4bar = 1.8
alter VB5 = 0
alter VB5bar = 1.8
alter VB6 = 1.8
alter VB6bar = 0
alter VB7 = 1.8
alter VB7bar = 0
op
echo REF_CODE_147
print v(n0) i(VREF) i(VDD)
alter VB0 = 1.8
alter VB0bar = 0
alter VB1 = 0
alter VB1bar = 1.8
alter VB2 = 0
alter VB2bar = 1.8
alter VB3 = 1.8
alter VB3bar = 0
alter VB4 = 0
alter VB4bar = 1.8
alter VB5 = 1.8
alter VB5bar = 0
alter VB6 = 0
alter VB6bar = 1.8
alter VB7 = 0
alter VB7bar = 1.8
op
echo REF_CODE_148
print v(n0) i(VREF) i(VDD)
alter VB0 = 1.8
alter VB0bar = 0
alter VB1 = 0
alter VB1bar = 1.8
alter VB2 = 0
alter VB2bar = 1.8
alter VB3 = 1.8
alter VB3bar = 0
alter VB4 = 0
alter VB4bar = 1.8
alter VB5 = 1.8
alter VB5bar = 0
alter VB6 = 0
alter VB6bar = 1.8
alter VB7 = 1.8
alter VB7bar = 0
op
echo REF_CODE_149
print v(n0) i(VREF) i(VDD)
alter VB0 = 1.8
alter VB0bar = 0
alter VB1 = 0
alter VB1bar = 1.8
alter VB2 = 0
alter VB2bar = 1.8
alter VB3 = 1.8
alter VB3bar = 0
alter VB4 = 0
alter VB4bar = 1.8
alter VB5 = 1.8
alter VB5bar = 0
alter VB6 = 1.8
alter VB6bar = 0
alter VB7 = 0
alter VB7bar = 1.8
op
echo REF_CODE_150
print v(n0) i(VREF) i(VDD)
alter VB0 = 1.8
alter VB0bar = 0
alter VB1 = 0
alter VB1bar = 1.8
alter VB2 = 0
alter VB2bar = 1.8
alter VB3 = 1.8
alter VB3bar = 0
alter VB4 = 0
alter VB4bar = 1.8
alter VB5 = 1.8
alter VB5bar = 0
alter VB6 = 1.8
alter VB6bar = 0
alter VB7 = 1.8
alter VB7bar = 0
op
echo REF_CODE_151
print v(n0) i(VREF) i(VDD)
alter VB0 = 1.8
alter VB0bar = 0
alter VB1 = 0
alter VB1bar = 1.8
alter VB2 = 0
alter VB2bar = 1.8
alter VB3 = 1.8
alter VB3bar = 0
alter VB4 = 1.8
alter VB4bar = 0
alter VB5 = 0
alter VB5bar = 1.8
alter VB6 = 0
alter VB6bar = 1.8
alter VB7 = 0
alter VB7bar = 1.8
op
echo REF_CODE_152
print v(n0) i(VREF) i(VDD)
alter VB0 = 1.8
alter VB0bar = 0
alter VB1 = 0
alter VB1bar = 1.8
alter VB2 = 0
alter VB2bar = 1.8
alter VB3 = 1.8
alter VB3bar = 0
alter VB4 = 1.8
alter VB4bar = 0
alter VB5 = 0
alter VB5bar = 1.8
alter VB6 = 0
alter VB6bar = 1.8
alter VB7 = 1.8
alter VB7bar = 0
op
echo REF_CODE_153
print v(n0) i(VREF) i(VDD)
alter VB0 = 1.8
alter VB0bar = 0
alter VB1 = 0
alter VB1bar = 1.8
alter VB2 = 0
alter VB2bar = 1.8
alter VB3 = 1.8
alter VB3bar = 0
alter VB4 = 1.8
alter VB4bar = 0
alter VB5 = 0
alter VB5bar = 1.8
alter VB6 = 1.8
alter VB6bar = 0
alter VB7 = 0
alter VB7bar = 1.8
op
echo REF_CODE_154
print v(n0) i(VREF) i(VDD)
alter VB0 = 1.8
alter VB0bar = 0
alter VB1 = 0
alter VB1bar = 1.8
alter VB2 = 0
alter VB2bar = 1.8
alter VB3 = 1.8
alter VB3bar = 0
alter VB4 = 1.8
alter VB4bar = 0
alter VB5 = 0
alter VB5bar = 1.8
alter VB6 = 1.8
alter VB6bar = 0
alter VB7 = 1.8
alter VB7bar = 0
op
echo REF_CODE_155
print v(n0) i(VREF) i(VDD)
alter VB0 = 1.8
alter VB0bar = 0
alter VB1 = 0
alter VB1bar = 1.8
alter VB2 = 0
alter VB2bar = 1.8
alter VB3 = 1.8
alter VB3bar = 0
alter VB4 = 1.8
alter VB4bar = 0
alter VB5 = 1.8
alter VB5bar = 0
alter VB6 = 0
alter VB6bar = 1.8
alter VB7 = 0
alter VB7bar = 1.8
op
echo REF_CODE_156
print v(n0) i(VREF) i(VDD)
alter VB0 = 1.8
alter VB0bar = 0
alter VB1 = 0
alter VB1bar = 1.8
alter VB2 = 0
alter VB2bar = 1.8
alter VB3 = 1.8
alter VB3bar = 0
alter VB4 = 1.8
alter VB4bar = 0
alter VB5 = 1.8
alter VB5bar = 0
alter VB6 = 0
alter VB6bar = 1.8
alter VB7 = 1.8
alter VB7bar = 0
op
echo REF_CODE_157
print v(n0) i(VREF) i(VDD)
alter VB0 = 1.8
alter VB0bar = 0
alter VB1 = 0
alter VB1bar = 1.8
alter VB2 = 0
alter VB2bar = 1.8
alter VB3 = 1.8
alter VB3bar = 0
alter VB4 = 1.8
alter VB4bar = 0
alter VB5 = 1.8
alter VB5bar = 0
alter VB6 = 1.8
alter VB6bar = 0
alter VB7 = 0
alter VB7bar = 1.8
op
echo REF_CODE_158
print v(n0) i(VREF) i(VDD)
alter VB0 = 1.8
alter VB0bar = 0
alter VB1 = 0
alter VB1bar = 1.8
alter VB2 = 0
alter VB2bar = 1.8
alter VB3 = 1.8
alter VB3bar = 0
alter VB4 = 1.8
alter VB4bar = 0
alter VB5 = 1.8
alter VB5bar = 0
alter VB6 = 1.8
alter VB6bar = 0
alter VB7 = 1.8
alter VB7bar = 0
op
echo REF_CODE_159
print v(n0) i(VREF) i(VDD)
alter VB0 = 1.8
alter VB0bar = 0
alter VB1 = 0
alter VB1bar = 1.8
alter VB2 = 1.8
alter VB2bar = 0
alter VB3 = 0
alter VB3bar = 1.8
alter VB4 = 0
alter VB4bar = 1.8
alter VB5 = 0
alter VB5bar = 1.8
alter VB6 = 0
alter VB6bar = 1.8
alter VB7 = 0
alter VB7bar = 1.8
op
echo REF_CODE_160
print v(n0) i(VREF) i(VDD)
alter VB0 = 1.8
alter VB0bar = 0
alter VB1 = 0
alter VB1bar = 1.8
alter VB2 = 1.8
alter VB2bar = 0
alter VB3 = 0
alter VB3bar = 1.8
alter VB4 = 0
alter VB4bar = 1.8
alter VB5 = 0
alter VB5bar = 1.8
alter VB6 = 0
alter VB6bar = 1.8
alter VB7 = 1.8
alter VB7bar = 0
op
echo REF_CODE_161
print v(n0) i(VREF) i(VDD)
alter VB0 = 1.8
alter VB0bar = 0
alter VB1 = 0
alter VB1bar = 1.8
alter VB2 = 1.8
alter VB2bar = 0
alter VB3 = 0
alter VB3bar = 1.8
alter VB4 = 0
alter VB4bar = 1.8
alter VB5 = 0
alter VB5bar = 1.8
alter VB6 = 1.8
alter VB6bar = 0
alter VB7 = 0
alter VB7bar = 1.8
op
echo REF_CODE_162
print v(n0) i(VREF) i(VDD)
alter VB0 = 1.8
alter VB0bar = 0
alter VB1 = 0
alter VB1bar = 1.8
alter VB2 = 1.8
alter VB2bar = 0
alter VB3 = 0
alter VB3bar = 1.8
alter VB4 = 0
alter VB4bar = 1.8
alter VB5 = 0
alter VB5bar = 1.8
alter VB6 = 1.8
alter VB6bar = 0
alter VB7 = 1.8
alter VB7bar = 0
op
echo REF_CODE_163
print v(n0) i(VREF) i(VDD)
alter VB0 = 1.8
alter VB0bar = 0
alter VB1 = 0
alter VB1bar = 1.8
alter VB2 = 1.8
alter VB2bar = 0
alter VB3 = 0
alter VB3bar = 1.8
alter VB4 = 0
alter VB4bar = 1.8
alter VB5 = 1.8
alter VB5bar = 0
alter VB6 = 0
alter VB6bar = 1.8
alter VB7 = 0
alter VB7bar = 1.8
op
echo REF_CODE_164
print v(n0) i(VREF) i(VDD)
alter VB0 = 1.8
alter VB0bar = 0
alter VB1 = 0
alter VB1bar = 1.8
alter VB2 = 1.8
alter VB2bar = 0
alter VB3 = 0
alter VB3bar = 1.8
alter VB4 = 0
alter VB4bar = 1.8
alter VB5 = 1.8
alter VB5bar = 0
alter VB6 = 0
alter VB6bar = 1.8
alter VB7 = 1.8
alter VB7bar = 0
op
echo REF_CODE_165
print v(n0) i(VREF) i(VDD)
alter VB0 = 1.8
alter VB0bar = 0
alter VB1 = 0
alter VB1bar = 1.8
alter VB2 = 1.8
alter VB2bar = 0
alter VB3 = 0
alter VB3bar = 1.8
alter VB4 = 0
alter VB4bar = 1.8
alter VB5 = 1.8
alter VB5bar = 0
alter VB6 = 1.8
alter VB6bar = 0
alter VB7 = 0
alter VB7bar = 1.8
op
echo REF_CODE_166
print v(n0) i(VREF) i(VDD)
alter VB0 = 1.8
alter VB0bar = 0
alter VB1 = 0
alter VB1bar = 1.8
alter VB2 = 1.8
alter VB2bar = 0
alter VB3 = 0
alter VB3bar = 1.8
alter VB4 = 0
alter VB4bar = 1.8
alter VB5 = 1.8
alter VB5bar = 0
alter VB6 = 1.8
alter VB6bar = 0
alter VB7 = 1.8
alter VB7bar = 0
op
echo REF_CODE_167
print v(n0) i(VREF) i(VDD)
alter VB0 = 1.8
alter VB0bar = 0
alter VB1 = 0
alter VB1bar = 1.8
alter VB2 = 1.8
alter VB2bar = 0
alter VB3 = 0
alter VB3bar = 1.8
alter VB4 = 1.8
alter VB4bar = 0
alter VB5 = 0
alter VB5bar = 1.8
alter VB6 = 0
alter VB6bar = 1.8
alter VB7 = 0
alter VB7bar = 1.8
op
echo REF_CODE_168
print v(n0) i(VREF) i(VDD)
alter VB0 = 1.8
alter VB0bar = 0
alter VB1 = 0
alter VB1bar = 1.8
alter VB2 = 1.8
alter VB2bar = 0
alter VB3 = 0
alter VB3bar = 1.8
alter VB4 = 1.8
alter VB4bar = 0
alter VB5 = 0
alter VB5bar = 1.8
alter VB6 = 0
alter VB6bar = 1.8
alter VB7 = 1.8
alter VB7bar = 0
op
echo REF_CODE_169
print v(n0) i(VREF) i(VDD)
alter VB0 = 1.8
alter VB0bar = 0
alter VB1 = 0
alter VB1bar = 1.8
alter VB2 = 1.8
alter VB2bar = 0
alter VB3 = 0
alter VB3bar = 1.8
alter VB4 = 1.8
alter VB4bar = 0
alter VB5 = 0
alter VB5bar = 1.8
alter VB6 = 1.8
alter VB6bar = 0
alter VB7 = 0
alter VB7bar = 1.8
op
echo REF_CODE_170
print v(n0) i(VREF) i(VDD)
alter VB0 = 1.8
alter VB0bar = 0
alter VB1 = 0
alter VB1bar = 1.8
alter VB2 = 1.8
alter VB2bar = 0
alter VB3 = 0
alter VB3bar = 1.8
alter VB4 = 1.8
alter VB4bar = 0
alter VB5 = 0
alter VB5bar = 1.8
alter VB6 = 1.8
alter VB6bar = 0
alter VB7 = 1.8
alter VB7bar = 0
op
echo REF_CODE_171
print v(n0) i(VREF) i(VDD)
alter VB0 = 1.8
alter VB0bar = 0
alter VB1 = 0
alter VB1bar = 1.8
alter VB2 = 1.8
alter VB2bar = 0
alter VB3 = 0
alter VB3bar = 1.8
alter VB4 = 1.8
alter VB4bar = 0
alter VB5 = 1.8
alter VB5bar = 0
alter VB6 = 0
alter VB6bar = 1.8
alter VB7 = 0
alter VB7bar = 1.8
op
echo REF_CODE_172
print v(n0) i(VREF) i(VDD)
alter VB0 = 1.8
alter VB0bar = 0
alter VB1 = 0
alter VB1bar = 1.8
alter VB2 = 1.8
alter VB2bar = 0
alter VB3 = 0
alter VB3bar = 1.8
alter VB4 = 1.8
alter VB4bar = 0
alter VB5 = 1.8
alter VB5bar = 0
alter VB6 = 0
alter VB6bar = 1.8
alter VB7 = 1.8
alter VB7bar = 0
op
echo REF_CODE_173
print v(n0) i(VREF) i(VDD)
alter VB0 = 1.8
alter VB0bar = 0
alter VB1 = 0
alter VB1bar = 1.8
alter VB2 = 1.8
alter VB2bar = 0
alter VB3 = 0
alter VB3bar = 1.8
alter VB4 = 1.8
alter VB4bar = 0
alter VB5 = 1.8
alter VB5bar = 0
alter VB6 = 1.8
alter VB6bar = 0
alter VB7 = 0
alter VB7bar = 1.8
op
echo REF_CODE_174
print v(n0) i(VREF) i(VDD)
alter VB0 = 1.8
alter VB0bar = 0
alter VB1 = 0
alter VB1bar = 1.8
alter VB2 = 1.8
alter VB2bar = 0
alter VB3 = 0
alter VB3bar = 1.8
alter VB4 = 1.8
alter VB4bar = 0
alter VB5 = 1.8
alter VB5bar = 0
alter VB6 = 1.8
alter VB6bar = 0
alter VB7 = 1.8
alter VB7bar = 0
op
echo REF_CODE_175
print v(n0) i(VREF) i(VDD)
alter VB0 = 1.8
alter VB0bar = 0
alter VB1 = 0
alter VB1bar = 1.8
alter VB2 = 1.8
alter VB2bar = 0
alter VB3 = 1.8
alter VB3bar = 0
alter VB4 = 0
alter VB4bar = 1.8
alter VB5 = 0
alter VB5bar = 1.8
alter VB6 = 0
alter VB6bar = 1.8
alter VB7 = 0
alter VB7bar = 1.8
op
echo REF_CODE_176
print v(n0) i(VREF) i(VDD)
alter VB0 = 1.8
alter VB0bar = 0
alter VB1 = 0
alter VB1bar = 1.8
alter VB2 = 1.8
alter VB2bar = 0
alter VB3 = 1.8
alter VB3bar = 0
alter VB4 = 0
alter VB4bar = 1.8
alter VB5 = 0
alter VB5bar = 1.8
alter VB6 = 0
alter VB6bar = 1.8
alter VB7 = 1.8
alter VB7bar = 0
op
echo REF_CODE_177
print v(n0) i(VREF) i(VDD)
alter VB0 = 1.8
alter VB0bar = 0
alter VB1 = 0
alter VB1bar = 1.8
alter VB2 = 1.8
alter VB2bar = 0
alter VB3 = 1.8
alter VB3bar = 0
alter VB4 = 0
alter VB4bar = 1.8
alter VB5 = 0
alter VB5bar = 1.8
alter VB6 = 1.8
alter VB6bar = 0
alter VB7 = 0
alter VB7bar = 1.8
op
echo REF_CODE_178
print v(n0) i(VREF) i(VDD)
alter VB0 = 1.8
alter VB0bar = 0
alter VB1 = 0
alter VB1bar = 1.8
alter VB2 = 1.8
alter VB2bar = 0
alter VB3 = 1.8
alter VB3bar = 0
alter VB4 = 0
alter VB4bar = 1.8
alter VB5 = 0
alter VB5bar = 1.8
alter VB6 = 1.8
alter VB6bar = 0
alter VB7 = 1.8
alter VB7bar = 0
op
echo REF_CODE_179
print v(n0) i(VREF) i(VDD)
alter VB0 = 1.8
alter VB0bar = 0
alter VB1 = 0
alter VB1bar = 1.8
alter VB2 = 1.8
alter VB2bar = 0
alter VB3 = 1.8
alter VB3bar = 0
alter VB4 = 0
alter VB4bar = 1.8
alter VB5 = 1.8
alter VB5bar = 0
alter VB6 = 0
alter VB6bar = 1.8
alter VB7 = 0
alter VB7bar = 1.8
op
echo REF_CODE_180
print v(n0) i(VREF) i(VDD)
alter VB0 = 1.8
alter VB0bar = 0
alter VB1 = 0
alter VB1bar = 1.8
alter VB2 = 1.8
alter VB2bar = 0
alter VB3 = 1.8
alter VB3bar = 0
alter VB4 = 0
alter VB4bar = 1.8
alter VB5 = 1.8
alter VB5bar = 0
alter VB6 = 0
alter VB6bar = 1.8
alter VB7 = 1.8
alter VB7bar = 0
op
echo REF_CODE_181
print v(n0) i(VREF) i(VDD)
alter VB0 = 1.8
alter VB0bar = 0
alter VB1 = 0
alter VB1bar = 1.8
alter VB2 = 1.8
alter VB2bar = 0
alter VB3 = 1.8
alter VB3bar = 0
alter VB4 = 0
alter VB4bar = 1.8
alter VB5 = 1.8
alter VB5bar = 0
alter VB6 = 1.8
alter VB6bar = 0
alter VB7 = 0
alter VB7bar = 1.8
op
echo REF_CODE_182
print v(n0) i(VREF) i(VDD)
alter VB0 = 1.8
alter VB0bar = 0
alter VB1 = 0
alter VB1bar = 1.8
alter VB2 = 1.8
alter VB2bar = 0
alter VB3 = 1.8
alter VB3bar = 0
alter VB4 = 0
alter VB4bar = 1.8
alter VB5 = 1.8
alter VB5bar = 0
alter VB6 = 1.8
alter VB6bar = 0
alter VB7 = 1.8
alter VB7bar = 0
op
echo REF_CODE_183
print v(n0) i(VREF) i(VDD)
alter VB0 = 1.8
alter VB0bar = 0
alter VB1 = 0
alter VB1bar = 1.8
alter VB2 = 1.8
alter VB2bar = 0
alter VB3 = 1.8
alter VB3bar = 0
alter VB4 = 1.8
alter VB4bar = 0
alter VB5 = 0
alter VB5bar = 1.8
alter VB6 = 0
alter VB6bar = 1.8
alter VB7 = 0
alter VB7bar = 1.8
op
echo REF_CODE_184
print v(n0) i(VREF) i(VDD)
alter VB0 = 1.8
alter VB0bar = 0
alter VB1 = 0
alter VB1bar = 1.8
alter VB2 = 1.8
alter VB2bar = 0
alter VB3 = 1.8
alter VB3bar = 0
alter VB4 = 1.8
alter VB4bar = 0
alter VB5 = 0
alter VB5bar = 1.8
alter VB6 = 0
alter VB6bar = 1.8
alter VB7 = 1.8
alter VB7bar = 0
op
echo REF_CODE_185
print v(n0) i(VREF) i(VDD)
alter VB0 = 1.8
alter VB0bar = 0
alter VB1 = 0
alter VB1bar = 1.8
alter VB2 = 1.8
alter VB2bar = 0
alter VB3 = 1.8
alter VB3bar = 0
alter VB4 = 1.8
alter VB4bar = 0
alter VB5 = 0
alter VB5bar = 1.8
alter VB6 = 1.8
alter VB6bar = 0
alter VB7 = 0
alter VB7bar = 1.8
op
echo REF_CODE_186
print v(n0) i(VREF) i(VDD)
alter VB0 = 1.8
alter VB0bar = 0
alter VB1 = 0
alter VB1bar = 1.8
alter VB2 = 1.8
alter VB2bar = 0
alter VB3 = 1.8
alter VB3bar = 0
alter VB4 = 1.8
alter VB4bar = 0
alter VB5 = 0
alter VB5bar = 1.8
alter VB6 = 1.8
alter VB6bar = 0
alter VB7 = 1.8
alter VB7bar = 0
op
echo REF_CODE_187
print v(n0) i(VREF) i(VDD)
alter VB0 = 1.8
alter VB0bar = 0
alter VB1 = 0
alter VB1bar = 1.8
alter VB2 = 1.8
alter VB2bar = 0
alter VB3 = 1.8
alter VB3bar = 0
alter VB4 = 1.8
alter VB4bar = 0
alter VB5 = 1.8
alter VB5bar = 0
alter VB6 = 0
alter VB6bar = 1.8
alter VB7 = 0
alter VB7bar = 1.8
op
echo REF_CODE_188
print v(n0) i(VREF) i(VDD)
alter VB0 = 1.8
alter VB0bar = 0
alter VB1 = 0
alter VB1bar = 1.8
alter VB2 = 1.8
alter VB2bar = 0
alter VB3 = 1.8
alter VB3bar = 0
alter VB4 = 1.8
alter VB4bar = 0
alter VB5 = 1.8
alter VB5bar = 0
alter VB6 = 0
alter VB6bar = 1.8
alter VB7 = 1.8
alter VB7bar = 0
op
echo REF_CODE_189
print v(n0) i(VREF) i(VDD)
alter VB0 = 1.8
alter VB0bar = 0
alter VB1 = 0
alter VB1bar = 1.8
alter VB2 = 1.8
alter VB2bar = 0
alter VB3 = 1.8
alter VB3bar = 0
alter VB4 = 1.8
alter VB4bar = 0
alter VB5 = 1.8
alter VB5bar = 0
alter VB6 = 1.8
alter VB6bar = 0
alter VB7 = 0
alter VB7bar = 1.8
op
echo REF_CODE_190
print v(n0) i(VREF) i(VDD)
alter VB0 = 1.8
alter VB0bar = 0
alter VB1 = 0
alter VB1bar = 1.8
alter VB2 = 1.8
alter VB2bar = 0
alter VB3 = 1.8
alter VB3bar = 0
alter VB4 = 1.8
alter VB4bar = 0
alter VB5 = 1.8
alter VB5bar = 0
alter VB6 = 1.8
alter VB6bar = 0
alter VB7 = 1.8
alter VB7bar = 0
op
echo REF_CODE_191
print v(n0) i(VREF) i(VDD)
alter VB0 = 1.8
alter VB0bar = 0
alter VB1 = 1.8
alter VB1bar = 0
alter VB2 = 0
alter VB2bar = 1.8
alter VB3 = 0
alter VB3bar = 1.8
alter VB4 = 0
alter VB4bar = 1.8
alter VB5 = 0
alter VB5bar = 1.8
alter VB6 = 0
alter VB6bar = 1.8
alter VB7 = 0
alter VB7bar = 1.8
op
echo REF_CODE_192
print v(n0) i(VREF) i(VDD)
alter VB0 = 1.8
alter VB0bar = 0
alter VB1 = 1.8
alter VB1bar = 0
alter VB2 = 0
alter VB2bar = 1.8
alter VB3 = 0
alter VB3bar = 1.8
alter VB4 = 0
alter VB4bar = 1.8
alter VB5 = 0
alter VB5bar = 1.8
alter VB6 = 0
alter VB6bar = 1.8
alter VB7 = 1.8
alter VB7bar = 0
op
echo REF_CODE_193
print v(n0) i(VREF) i(VDD)
alter VB0 = 1.8
alter VB0bar = 0
alter VB1 = 1.8
alter VB1bar = 0
alter VB2 = 0
alter VB2bar = 1.8
alter VB3 = 0
alter VB3bar = 1.8
alter VB4 = 0
alter VB4bar = 1.8
alter VB5 = 0
alter VB5bar = 1.8
alter VB6 = 1.8
alter VB6bar = 0
alter VB7 = 0
alter VB7bar = 1.8
op
echo REF_CODE_194
print v(n0) i(VREF) i(VDD)
alter VB0 = 1.8
alter VB0bar = 0
alter VB1 = 1.8
alter VB1bar = 0
alter VB2 = 0
alter VB2bar = 1.8
alter VB3 = 0
alter VB3bar = 1.8
alter VB4 = 0
alter VB4bar = 1.8
alter VB5 = 0
alter VB5bar = 1.8
alter VB6 = 1.8
alter VB6bar = 0
alter VB7 = 1.8
alter VB7bar = 0
op
echo REF_CODE_195
print v(n0) i(VREF) i(VDD)
alter VB0 = 1.8
alter VB0bar = 0
alter VB1 = 1.8
alter VB1bar = 0
alter VB2 = 0
alter VB2bar = 1.8
alter VB3 = 0
alter VB3bar = 1.8
alter VB4 = 0
alter VB4bar = 1.8
alter VB5 = 1.8
alter VB5bar = 0
alter VB6 = 0
alter VB6bar = 1.8
alter VB7 = 0
alter VB7bar = 1.8
op
echo REF_CODE_196
print v(n0) i(VREF) i(VDD)
alter VB0 = 1.8
alter VB0bar = 0
alter VB1 = 1.8
alter VB1bar = 0
alter VB2 = 0
alter VB2bar = 1.8
alter VB3 = 0
alter VB3bar = 1.8
alter VB4 = 0
alter VB4bar = 1.8
alter VB5 = 1.8
alter VB5bar = 0
alter VB6 = 0
alter VB6bar = 1.8
alter VB7 = 1.8
alter VB7bar = 0
op
echo REF_CODE_197
print v(n0) i(VREF) i(VDD)
alter VB0 = 1.8
alter VB0bar = 0
alter VB1 = 1.8
alter VB1bar = 0
alter VB2 = 0
alter VB2bar = 1.8
alter VB3 = 0
alter VB3bar = 1.8
alter VB4 = 0
alter VB4bar = 1.8
alter VB5 = 1.8
alter VB5bar = 0
alter VB6 = 1.8
alter VB6bar = 0
alter VB7 = 0
alter VB7bar = 1.8
op
echo REF_CODE_198
print v(n0) i(VREF) i(VDD)
alter VB0 = 1.8
alter VB0bar = 0
alter VB1 = 1.8
alter VB1bar = 0
alter VB2 = 0
alter VB2bar = 1.8
alter VB3 = 0
alter VB3bar = 1.8
alter VB4 = 0
alter VB4bar = 1.8
alter VB5 = 1.8
alter VB5bar = 0
alter VB6 = 1.8
alter VB6bar = 0
alter VB7 = 1.8
alter VB7bar = 0
op
echo REF_CODE_199
print v(n0) i(VREF) i(VDD)
alter VB0 = 1.8
alter VB0bar = 0
alter VB1 = 1.8
alter VB1bar = 0
alter VB2 = 0
alter VB2bar = 1.8
alter VB3 = 0
alter VB3bar = 1.8
alter VB4 = 1.8
alter VB4bar = 0
alter VB5 = 0
alter VB5bar = 1.8
alter VB6 = 0
alter VB6bar = 1.8
alter VB7 = 0
alter VB7bar = 1.8
op
echo REF_CODE_200
print v(n0) i(VREF) i(VDD)
alter VB0 = 1.8
alter VB0bar = 0
alter VB1 = 1.8
alter VB1bar = 0
alter VB2 = 0
alter VB2bar = 1.8
alter VB3 = 0
alter VB3bar = 1.8
alter VB4 = 1.8
alter VB4bar = 0
alter VB5 = 0
alter VB5bar = 1.8
alter VB6 = 0
alter VB6bar = 1.8
alter VB7 = 1.8
alter VB7bar = 0
op
echo REF_CODE_201
print v(n0) i(VREF) i(VDD)
alter VB0 = 1.8
alter VB0bar = 0
alter VB1 = 1.8
alter VB1bar = 0
alter VB2 = 0
alter VB2bar = 1.8
alter VB3 = 0
alter VB3bar = 1.8
alter VB4 = 1.8
alter VB4bar = 0
alter VB5 = 0
alter VB5bar = 1.8
alter VB6 = 1.8
alter VB6bar = 0
alter VB7 = 0
alter VB7bar = 1.8
op
echo REF_CODE_202
print v(n0) i(VREF) i(VDD)
alter VB0 = 1.8
alter VB0bar = 0
alter VB1 = 1.8
alter VB1bar = 0
alter VB2 = 0
alter VB2bar = 1.8
alter VB3 = 0
alter VB3bar = 1.8
alter VB4 = 1.8
alter VB4bar = 0
alter VB5 = 0
alter VB5bar = 1.8
alter VB6 = 1.8
alter VB6bar = 0
alter VB7 = 1.8
alter VB7bar = 0
op
echo REF_CODE_203
print v(n0) i(VREF) i(VDD)
alter VB0 = 1.8
alter VB0bar = 0
alter VB1 = 1.8
alter VB1bar = 0
alter VB2 = 0
alter VB2bar = 1.8
alter VB3 = 0
alter VB3bar = 1.8
alter VB4 = 1.8
alter VB4bar = 0
alter VB5 = 1.8
alter VB5bar = 0
alter VB6 = 0
alter VB6bar = 1.8
alter VB7 = 0
alter VB7bar = 1.8
op
echo REF_CODE_204
print v(n0) i(VREF) i(VDD)
alter VB0 = 1.8
alter VB0bar = 0
alter VB1 = 1.8
alter VB1bar = 0
alter VB2 = 0
alter VB2bar = 1.8
alter VB3 = 0
alter VB3bar = 1.8
alter VB4 = 1.8
alter VB4bar = 0
alter VB5 = 1.8
alter VB5bar = 0
alter VB6 = 0
alter VB6bar = 1.8
alter VB7 = 1.8
alter VB7bar = 0
op
echo REF_CODE_205
print v(n0) i(VREF) i(VDD)
alter VB0 = 1.8
alter VB0bar = 0
alter VB1 = 1.8
alter VB1bar = 0
alter VB2 = 0
alter VB2bar = 1.8
alter VB3 = 0
alter VB3bar = 1.8
alter VB4 = 1.8
alter VB4bar = 0
alter VB5 = 1.8
alter VB5bar = 0
alter VB6 = 1.8
alter VB6bar = 0
alter VB7 = 0
alter VB7bar = 1.8
op
echo REF_CODE_206
print v(n0) i(VREF) i(VDD)
alter VB0 = 1.8
alter VB0bar = 0
alter VB1 = 1.8
alter VB1bar = 0
alter VB2 = 0
alter VB2bar = 1.8
alter VB3 = 0
alter VB3bar = 1.8
alter VB4 = 1.8
alter VB4bar = 0
alter VB5 = 1.8
alter VB5bar = 0
alter VB6 = 1.8
alter VB6bar = 0
alter VB7 = 1.8
alter VB7bar = 0
op
echo REF_CODE_207
print v(n0) i(VREF) i(VDD)
alter VB0 = 1.8
alter VB0bar = 0
alter VB1 = 1.8
alter VB1bar = 0
alter VB2 = 0
alter VB2bar = 1.8
alter VB3 = 1.8
alter VB3bar = 0
alter VB4 = 0
alter VB4bar = 1.8
alter VB5 = 0
alter VB5bar = 1.8
alter VB6 = 0
alter VB6bar = 1.8
alter VB7 = 0
alter VB7bar = 1.8
op
echo REF_CODE_208
print v(n0) i(VREF) i(VDD)
alter VB0 = 1.8
alter VB0bar = 0
alter VB1 = 1.8
alter VB1bar = 0
alter VB2 = 0
alter VB2bar = 1.8
alter VB3 = 1.8
alter VB3bar = 0
alter VB4 = 0
alter VB4bar = 1.8
alter VB5 = 0
alter VB5bar = 1.8
alter VB6 = 0
alter VB6bar = 1.8
alter VB7 = 1.8
alter VB7bar = 0
op
echo REF_CODE_209
print v(n0) i(VREF) i(VDD)
alter VB0 = 1.8
alter VB0bar = 0
alter VB1 = 1.8
alter VB1bar = 0
alter VB2 = 0
alter VB2bar = 1.8
alter VB3 = 1.8
alter VB3bar = 0
alter VB4 = 0
alter VB4bar = 1.8
alter VB5 = 0
alter VB5bar = 1.8
alter VB6 = 1.8
alter VB6bar = 0
alter VB7 = 0
alter VB7bar = 1.8
op
echo REF_CODE_210
print v(n0) i(VREF) i(VDD)
alter VB0 = 1.8
alter VB0bar = 0
alter VB1 = 1.8
alter VB1bar = 0
alter VB2 = 0
alter VB2bar = 1.8
alter VB3 = 1.8
alter VB3bar = 0
alter VB4 = 0
alter VB4bar = 1.8
alter VB5 = 0
alter VB5bar = 1.8
alter VB6 = 1.8
alter VB6bar = 0
alter VB7 = 1.8
alter VB7bar = 0
op
echo REF_CODE_211
print v(n0) i(VREF) i(VDD)
alter VB0 = 1.8
alter VB0bar = 0
alter VB1 = 1.8
alter VB1bar = 0
alter VB2 = 0
alter VB2bar = 1.8
alter VB3 = 1.8
alter VB3bar = 0
alter VB4 = 0
alter VB4bar = 1.8
alter VB5 = 1.8
alter VB5bar = 0
alter VB6 = 0
alter VB6bar = 1.8
alter VB7 = 0
alter VB7bar = 1.8
op
echo REF_CODE_212
print v(n0) i(VREF) i(VDD)
alter VB0 = 1.8
alter VB0bar = 0
alter VB1 = 1.8
alter VB1bar = 0
alter VB2 = 0
alter VB2bar = 1.8
alter VB3 = 1.8
alter VB3bar = 0
alter VB4 = 0
alter VB4bar = 1.8
alter VB5 = 1.8
alter VB5bar = 0
alter VB6 = 0
alter VB6bar = 1.8
alter VB7 = 1.8
alter VB7bar = 0
op
echo REF_CODE_213
print v(n0) i(VREF) i(VDD)
alter VB0 = 1.8
alter VB0bar = 0
alter VB1 = 1.8
alter VB1bar = 0
alter VB2 = 0
alter VB2bar = 1.8
alter VB3 = 1.8
alter VB3bar = 0
alter VB4 = 0
alter VB4bar = 1.8
alter VB5 = 1.8
alter VB5bar = 0
alter VB6 = 1.8
alter VB6bar = 0
alter VB7 = 0
alter VB7bar = 1.8
op
echo REF_CODE_214
print v(n0) i(VREF) i(VDD)
alter VB0 = 1.8
alter VB0bar = 0
alter VB1 = 1.8
alter VB1bar = 0
alter VB2 = 0
alter VB2bar = 1.8
alter VB3 = 1.8
alter VB3bar = 0
alter VB4 = 0
alter VB4bar = 1.8
alter VB5 = 1.8
alter VB5bar = 0
alter VB6 = 1.8
alter VB6bar = 0
alter VB7 = 1.8
alter VB7bar = 0
op
echo REF_CODE_215
print v(n0) i(VREF) i(VDD)
alter VB0 = 1.8
alter VB0bar = 0
alter VB1 = 1.8
alter VB1bar = 0
alter VB2 = 0
alter VB2bar = 1.8
alter VB3 = 1.8
alter VB3bar = 0
alter VB4 = 1.8
alter VB4bar = 0
alter VB5 = 0
alter VB5bar = 1.8
alter VB6 = 0
alter VB6bar = 1.8
alter VB7 = 0
alter VB7bar = 1.8
op
echo REF_CODE_216
print v(n0) i(VREF) i(VDD)
alter VB0 = 1.8
alter VB0bar = 0
alter VB1 = 1.8
alter VB1bar = 0
alter VB2 = 0
alter VB2bar = 1.8
alter VB3 = 1.8
alter VB3bar = 0
alter VB4 = 1.8
alter VB4bar = 0
alter VB5 = 0
alter VB5bar = 1.8
alter VB6 = 0
alter VB6bar = 1.8
alter VB7 = 1.8
alter VB7bar = 0
op
echo REF_CODE_217
print v(n0) i(VREF) i(VDD)
alter VB0 = 1.8
alter VB0bar = 0
alter VB1 = 1.8
alter VB1bar = 0
alter VB2 = 0
alter VB2bar = 1.8
alter VB3 = 1.8
alter VB3bar = 0
alter VB4 = 1.8
alter VB4bar = 0
alter VB5 = 0
alter VB5bar = 1.8
alter VB6 = 1.8
alter VB6bar = 0
alter VB7 = 0
alter VB7bar = 1.8
op
echo REF_CODE_218
print v(n0) i(VREF) i(VDD)
alter VB0 = 1.8
alter VB0bar = 0
alter VB1 = 1.8
alter VB1bar = 0
alter VB2 = 0
alter VB2bar = 1.8
alter VB3 = 1.8
alter VB3bar = 0
alter VB4 = 1.8
alter VB4bar = 0
alter VB5 = 0
alter VB5bar = 1.8
alter VB6 = 1.8
alter VB6bar = 0
alter VB7 = 1.8
alter VB7bar = 0
op
echo REF_CODE_219
print v(n0) i(VREF) i(VDD)
alter VB0 = 1.8
alter VB0bar = 0
alter VB1 = 1.8
alter VB1bar = 0
alter VB2 = 0
alter VB2bar = 1.8
alter VB3 = 1.8
alter VB3bar = 0
alter VB4 = 1.8
alter VB4bar = 0
alter VB5 = 1.8
alter VB5bar = 0
alter VB6 = 0
alter VB6bar = 1.8
alter VB7 = 0
alter VB7bar = 1.8
op
echo REF_CODE_220
print v(n0) i(VREF) i(VDD)
alter VB0 = 1.8
alter VB0bar = 0
alter VB1 = 1.8
alter VB1bar = 0
alter VB2 = 0
alter VB2bar = 1.8
alter VB3 = 1.8
alter VB3bar = 0
alter VB4 = 1.8
alter VB4bar = 0
alter VB5 = 1.8
alter VB5bar = 0
alter VB6 = 0
alter VB6bar = 1.8
alter VB7 = 1.8
alter VB7bar = 0
op
echo REF_CODE_221
print v(n0) i(VREF) i(VDD)
alter VB0 = 1.8
alter VB0bar = 0
alter VB1 = 1.8
alter VB1bar = 0
alter VB2 = 0
alter VB2bar = 1.8
alter VB3 = 1.8
alter VB3bar = 0
alter VB4 = 1.8
alter VB4bar = 0
alter VB5 = 1.8
alter VB5bar = 0
alter VB6 = 1.8
alter VB6bar = 0
alter VB7 = 0
alter VB7bar = 1.8
op
echo REF_CODE_222
print v(n0) i(VREF) i(VDD)
alter VB0 = 1.8
alter VB0bar = 0
alter VB1 = 1.8
alter VB1bar = 0
alter VB2 = 0
alter VB2bar = 1.8
alter VB3 = 1.8
alter VB3bar = 0
alter VB4 = 1.8
alter VB4bar = 0
alter VB5 = 1.8
alter VB5bar = 0
alter VB6 = 1.8
alter VB6bar = 0
alter VB7 = 1.8
alter VB7bar = 0
op
echo REF_CODE_223
print v(n0) i(VREF) i(VDD)
alter VB0 = 1.8
alter VB0bar = 0
alter VB1 = 1.8
alter VB1bar = 0
alter VB2 = 1.8
alter VB2bar = 0
alter VB3 = 0
alter VB3bar = 1.8
alter VB4 = 0
alter VB4bar = 1.8
alter VB5 = 0
alter VB5bar = 1.8
alter VB6 = 0
alter VB6bar = 1.8
alter VB7 = 0
alter VB7bar = 1.8
op
echo REF_CODE_224
print v(n0) i(VREF) i(VDD)
alter VB0 = 1.8
alter VB0bar = 0
alter VB1 = 1.8
alter VB1bar = 0
alter VB2 = 1.8
alter VB2bar = 0
alter VB3 = 0
alter VB3bar = 1.8
alter VB4 = 0
alter VB4bar = 1.8
alter VB5 = 0
alter VB5bar = 1.8
alter VB6 = 0
alter VB6bar = 1.8
alter VB7 = 1.8
alter VB7bar = 0
op
echo REF_CODE_225
print v(n0) i(VREF) i(VDD)
alter VB0 = 1.8
alter VB0bar = 0
alter VB1 = 1.8
alter VB1bar = 0
alter VB2 = 1.8
alter VB2bar = 0
alter VB3 = 0
alter VB3bar = 1.8
alter VB4 = 0
alter VB4bar = 1.8
alter VB5 = 0
alter VB5bar = 1.8
alter VB6 = 1.8
alter VB6bar = 0
alter VB7 = 0
alter VB7bar = 1.8
op
echo REF_CODE_226
print v(n0) i(VREF) i(VDD)
alter VB0 = 1.8
alter VB0bar = 0
alter VB1 = 1.8
alter VB1bar = 0
alter VB2 = 1.8
alter VB2bar = 0
alter VB3 = 0
alter VB3bar = 1.8
alter VB4 = 0
alter VB4bar = 1.8
alter VB5 = 0
alter VB5bar = 1.8
alter VB6 = 1.8
alter VB6bar = 0
alter VB7 = 1.8
alter VB7bar = 0
op
echo REF_CODE_227
print v(n0) i(VREF) i(VDD)
alter VB0 = 1.8
alter VB0bar = 0
alter VB1 = 1.8
alter VB1bar = 0
alter VB2 = 1.8
alter VB2bar = 0
alter VB3 = 0
alter VB3bar = 1.8
alter VB4 = 0
alter VB4bar = 1.8
alter VB5 = 1.8
alter VB5bar = 0
alter VB6 = 0
alter VB6bar = 1.8
alter VB7 = 0
alter VB7bar = 1.8
op
echo REF_CODE_228
print v(n0) i(VREF) i(VDD)
alter VB0 = 1.8
alter VB0bar = 0
alter VB1 = 1.8
alter VB1bar = 0
alter VB2 = 1.8
alter VB2bar = 0
alter VB3 = 0
alter VB3bar = 1.8
alter VB4 = 0
alter VB4bar = 1.8
alter VB5 = 1.8
alter VB5bar = 0
alter VB6 = 0
alter VB6bar = 1.8
alter VB7 = 1.8
alter VB7bar = 0
op
echo REF_CODE_229
print v(n0) i(VREF) i(VDD)
alter VB0 = 1.8
alter VB0bar = 0
alter VB1 = 1.8
alter VB1bar = 0
alter VB2 = 1.8
alter VB2bar = 0
alter VB3 = 0
alter VB3bar = 1.8
alter VB4 = 0
alter VB4bar = 1.8
alter VB5 = 1.8
alter VB5bar = 0
alter VB6 = 1.8
alter VB6bar = 0
alter VB7 = 0
alter VB7bar = 1.8
op
echo REF_CODE_230
print v(n0) i(VREF) i(VDD)
alter VB0 = 1.8
alter VB0bar = 0
alter VB1 = 1.8
alter VB1bar = 0
alter VB2 = 1.8
alter VB2bar = 0
alter VB3 = 0
alter VB3bar = 1.8
alter VB4 = 0
alter VB4bar = 1.8
alter VB5 = 1.8
alter VB5bar = 0
alter VB6 = 1.8
alter VB6bar = 0
alter VB7 = 1.8
alter VB7bar = 0
op
echo REF_CODE_231
print v(n0) i(VREF) i(VDD)
alter VB0 = 1.8
alter VB0bar = 0
alter VB1 = 1.8
alter VB1bar = 0
alter VB2 = 1.8
alter VB2bar = 0
alter VB3 = 0
alter VB3bar = 1.8
alter VB4 = 1.8
alter VB4bar = 0
alter VB5 = 0
alter VB5bar = 1.8
alter VB6 = 0
alter VB6bar = 1.8
alter VB7 = 0
alter VB7bar = 1.8
op
echo REF_CODE_232
print v(n0) i(VREF) i(VDD)
alter VB0 = 1.8
alter VB0bar = 0
alter VB1 = 1.8
alter VB1bar = 0
alter VB2 = 1.8
alter VB2bar = 0
alter VB3 = 0
alter VB3bar = 1.8
alter VB4 = 1.8
alter VB4bar = 0
alter VB5 = 0
alter VB5bar = 1.8
alter VB6 = 0
alter VB6bar = 1.8
alter VB7 = 1.8
alter VB7bar = 0
op
echo REF_CODE_233
print v(n0) i(VREF) i(VDD)
alter VB0 = 1.8
alter VB0bar = 0
alter VB1 = 1.8
alter VB1bar = 0
alter VB2 = 1.8
alter VB2bar = 0
alter VB3 = 0
alter VB3bar = 1.8
alter VB4 = 1.8
alter VB4bar = 0
alter VB5 = 0
alter VB5bar = 1.8
alter VB6 = 1.8
alter VB6bar = 0
alter VB7 = 0
alter VB7bar = 1.8
op
echo REF_CODE_234
print v(n0) i(VREF) i(VDD)
alter VB0 = 1.8
alter VB0bar = 0
alter VB1 = 1.8
alter VB1bar = 0
alter VB2 = 1.8
alter VB2bar = 0
alter VB3 = 0
alter VB3bar = 1.8
alter VB4 = 1.8
alter VB4bar = 0
alter VB5 = 0
alter VB5bar = 1.8
alter VB6 = 1.8
alter VB6bar = 0
alter VB7 = 1.8
alter VB7bar = 0
op
echo REF_CODE_235
print v(n0) i(VREF) i(VDD)
alter VB0 = 1.8
alter VB0bar = 0
alter VB1 = 1.8
alter VB1bar = 0
alter VB2 = 1.8
alter VB2bar = 0
alter VB3 = 0
alter VB3bar = 1.8
alter VB4 = 1.8
alter VB4bar = 0
alter VB5 = 1.8
alter VB5bar = 0
alter VB6 = 0
alter VB6bar = 1.8
alter VB7 = 0
alter VB7bar = 1.8
op
echo REF_CODE_236
print v(n0) i(VREF) i(VDD)
alter VB0 = 1.8
alter VB0bar = 0
alter VB1 = 1.8
alter VB1bar = 0
alter VB2 = 1.8
alter VB2bar = 0
alter VB3 = 0
alter VB3bar = 1.8
alter VB4 = 1.8
alter VB4bar = 0
alter VB5 = 1.8
alter VB5bar = 0
alter VB6 = 0
alter VB6bar = 1.8
alter VB7 = 1.8
alter VB7bar = 0
op
echo REF_CODE_237
print v(n0) i(VREF) i(VDD)
alter VB0 = 1.8
alter VB0bar = 0
alter VB1 = 1.8
alter VB1bar = 0
alter VB2 = 1.8
alter VB2bar = 0
alter VB3 = 0
alter VB3bar = 1.8
alter VB4 = 1.8
alter VB4bar = 0
alter VB5 = 1.8
alter VB5bar = 0
alter VB6 = 1.8
alter VB6bar = 0
alter VB7 = 0
alter VB7bar = 1.8
op
echo REF_CODE_238
print v(n0) i(VREF) i(VDD)
alter VB0 = 1.8
alter VB0bar = 0
alter VB1 = 1.8
alter VB1bar = 0
alter VB2 = 1.8
alter VB2bar = 0
alter VB3 = 0
alter VB3bar = 1.8
alter VB4 = 1.8
alter VB4bar = 0
alter VB5 = 1.8
alter VB5bar = 0
alter VB6 = 1.8
alter VB6bar = 0
alter VB7 = 1.8
alter VB7bar = 0
op
echo REF_CODE_239
print v(n0) i(VREF) i(VDD)
alter VB0 = 1.8
alter VB0bar = 0
alter VB1 = 1.8
alter VB1bar = 0
alter VB2 = 1.8
alter VB2bar = 0
alter VB3 = 1.8
alter VB3bar = 0
alter VB4 = 0
alter VB4bar = 1.8
alter VB5 = 0
alter VB5bar = 1.8
alter VB6 = 0
alter VB6bar = 1.8
alter VB7 = 0
alter VB7bar = 1.8
op
echo REF_CODE_240
print v(n0) i(VREF) i(VDD)
alter VB0 = 1.8
alter VB0bar = 0
alter VB1 = 1.8
alter VB1bar = 0
alter VB2 = 1.8
alter VB2bar = 0
alter VB3 = 1.8
alter VB3bar = 0
alter VB4 = 0
alter VB4bar = 1.8
alter VB5 = 0
alter VB5bar = 1.8
alter VB6 = 0
alter VB6bar = 1.8
alter VB7 = 1.8
alter VB7bar = 0
op
echo REF_CODE_241
print v(n0) i(VREF) i(VDD)
alter VB0 = 1.8
alter VB0bar = 0
alter VB1 = 1.8
alter VB1bar = 0
alter VB2 = 1.8
alter VB2bar = 0
alter VB3 = 1.8
alter VB3bar = 0
alter VB4 = 0
alter VB4bar = 1.8
alter VB5 = 0
alter VB5bar = 1.8
alter VB6 = 1.8
alter VB6bar = 0
alter VB7 = 0
alter VB7bar = 1.8
op
echo REF_CODE_242
print v(n0) i(VREF) i(VDD)
alter VB0 = 1.8
alter VB0bar = 0
alter VB1 = 1.8
alter VB1bar = 0
alter VB2 = 1.8
alter VB2bar = 0
alter VB3 = 1.8
alter VB3bar = 0
alter VB4 = 0
alter VB4bar = 1.8
alter VB5 = 0
alter VB5bar = 1.8
alter VB6 = 1.8
alter VB6bar = 0
alter VB7 = 1.8
alter VB7bar = 0
op
echo REF_CODE_243
print v(n0) i(VREF) i(VDD)
alter VB0 = 1.8
alter VB0bar = 0
alter VB1 = 1.8
alter VB1bar = 0
alter VB2 = 1.8
alter VB2bar = 0
alter VB3 = 1.8
alter VB3bar = 0
alter VB4 = 0
alter VB4bar = 1.8
alter VB5 = 1.8
alter VB5bar = 0
alter VB6 = 0
alter VB6bar = 1.8
alter VB7 = 0
alter VB7bar = 1.8
op
echo REF_CODE_244
print v(n0) i(VREF) i(VDD)
alter VB0 = 1.8
alter VB0bar = 0
alter VB1 = 1.8
alter VB1bar = 0
alter VB2 = 1.8
alter VB2bar = 0
alter VB3 = 1.8
alter VB3bar = 0
alter VB4 = 0
alter VB4bar = 1.8
alter VB5 = 1.8
alter VB5bar = 0
alter VB6 = 0
alter VB6bar = 1.8
alter VB7 = 1.8
alter VB7bar = 0
op
echo REF_CODE_245
print v(n0) i(VREF) i(VDD)
alter VB0 = 1.8
alter VB0bar = 0
alter VB1 = 1.8
alter VB1bar = 0
alter VB2 = 1.8
alter VB2bar = 0
alter VB3 = 1.8
alter VB3bar = 0
alter VB4 = 0
alter VB4bar = 1.8
alter VB5 = 1.8
alter VB5bar = 0
alter VB6 = 1.8
alter VB6bar = 0
alter VB7 = 0
alter VB7bar = 1.8
op
echo REF_CODE_246
print v(n0) i(VREF) i(VDD)
alter VB0 = 1.8
alter VB0bar = 0
alter VB1 = 1.8
alter VB1bar = 0
alter VB2 = 1.8
alter VB2bar = 0
alter VB3 = 1.8
alter VB3bar = 0
alter VB4 = 0
alter VB4bar = 1.8
alter VB5 = 1.8
alter VB5bar = 0
alter VB6 = 1.8
alter VB6bar = 0
alter VB7 = 1.8
alter VB7bar = 0
op
echo REF_CODE_247
print v(n0) i(VREF) i(VDD)
alter VB0 = 1.8
alter VB0bar = 0
alter VB1 = 1.8
alter VB1bar = 0
alter VB2 = 1.8
alter VB2bar = 0
alter VB3 = 1.8
alter VB3bar = 0
alter VB4 = 1.8
alter VB4bar = 0
alter VB5 = 0
alter VB5bar = 1.8
alter VB6 = 0
alter VB6bar = 1.8
alter VB7 = 0
alter VB7bar = 1.8
op
echo REF_CODE_248
print v(n0) i(VREF) i(VDD)
alter VB0 = 1.8
alter VB0bar = 0
alter VB1 = 1.8
alter VB1bar = 0
alter VB2 = 1.8
alter VB2bar = 0
alter VB3 = 1.8
alter VB3bar = 0
alter VB4 = 1.8
alter VB4bar = 0
alter VB5 = 0
alter VB5bar = 1.8
alter VB6 = 0
alter VB6bar = 1.8
alter VB7 = 1.8
alter VB7bar = 0
op
echo REF_CODE_249
print v(n0) i(VREF) i(VDD)
alter VB0 = 1.8
alter VB0bar = 0
alter VB1 = 1.8
alter VB1bar = 0
alter VB2 = 1.8
alter VB2bar = 0
alter VB3 = 1.8
alter VB3bar = 0
alter VB4 = 1.8
alter VB4bar = 0
alter VB5 = 0
alter VB5bar = 1.8
alter VB6 = 1.8
alter VB6bar = 0
alter VB7 = 0
alter VB7bar = 1.8
op
echo REF_CODE_250
print v(n0) i(VREF) i(VDD)
alter VB0 = 1.8
alter VB0bar = 0
alter VB1 = 1.8
alter VB1bar = 0
alter VB2 = 1.8
alter VB2bar = 0
alter VB3 = 1.8
alter VB3bar = 0
alter VB4 = 1.8
alter VB4bar = 0
alter VB5 = 0
alter VB5bar = 1.8
alter VB6 = 1.8
alter VB6bar = 0
alter VB7 = 1.8
alter VB7bar = 0
op
echo REF_CODE_251
print v(n0) i(VREF) i(VDD)
alter VB0 = 1.8
alter VB0bar = 0
alter VB1 = 1.8
alter VB1bar = 0
alter VB2 = 1.8
alter VB2bar = 0
alter VB3 = 1.8
alter VB3bar = 0
alter VB4 = 1.8
alter VB4bar = 0
alter VB5 = 1.8
alter VB5bar = 0
alter VB6 = 0
alter VB6bar = 1.8
alter VB7 = 0
alter VB7bar = 1.8
op
echo REF_CODE_252
print v(n0) i(VREF) i(VDD)
alter VB0 = 1.8
alter VB0bar = 0
alter VB1 = 1.8
alter VB1bar = 0
alter VB2 = 1.8
alter VB2bar = 0
alter VB3 = 1.8
alter VB3bar = 0
alter VB4 = 1.8
alter VB4bar = 0
alter VB5 = 1.8
alter VB5bar = 0
alter VB6 = 0
alter VB6bar = 1.8
alter VB7 = 1.8
alter VB7bar = 0
op
echo REF_CODE_253
print v(n0) i(VREF) i(VDD)
alter VB0 = 1.8
alter VB0bar = 0
alter VB1 = 1.8
alter VB1bar = 0
alter VB2 = 1.8
alter VB2bar = 0
alter VB3 = 1.8
alter VB3bar = 0
alter VB4 = 1.8
alter VB4bar = 0
alter VB5 = 1.8
alter VB5bar = 0
alter VB6 = 1.8
alter VB6bar = 0
alter VB7 = 0
alter VB7bar = 1.8
op
echo REF_CODE_254
print v(n0) i(VREF) i(VDD)
alter VB0 = 1.8
alter VB0bar = 0
alter VB1 = 1.8
alter VB1bar = 0
alter VB2 = 1.8
alter VB2bar = 0
alter VB3 = 1.8
alter VB3bar = 0
alter VB4 = 1.8
alter VB4bar = 0
alter VB5 = 1.8
alter VB5bar = 0
alter VB6 = 1.8
alter VB6bar = 0
alter VB7 = 1.8
alter VB7bar = 0
op
echo REF_CODE_255
print v(n0) i(VREF) i(VDD)
quit
.endc
.end
