* Candidate 8-bit reference DAC: ideal resistors, SKY130 transmission gates.
.option scale=1u
.param mc_mm_switch=0 mc_pr_switch=0
.include "/home/mehtama1/eda-tools/pdks/sky130A/libs.ref/sky130_fd_pr/spice/sky130_fd_pr__nfet_01v8__tt.pm3.spice"
.include "/home/mehtama1/eda-tools/pdks/sky130A/libs.ref/sky130_fd_pr/spice/sky130_fd_pr__nfet_01v8__mismatch.corner.spice"
.include "/home/mehtama1/eda-tools/pdks/sky130A/libs.ref/sky130_fd_pr/spice/sky130_fd_pr__pfet_01v8__tt.corner.spice"
.include "/home/mehtama1/eda-tools/pdks/sky130A/libs.ref/sky130_fd_pr/spice/sky130_fd_pr__pfet_01v8__mismatch.corner.spice"
* SKY130 Spice File.
.option scale=1.0u
.include "/home/mehtama1/eda-tools/pdks/sky130A/libs.tech/ngspice/parameters/lod.spice"
.param
+ lv_dlc_rotweak = .00e-9
+ lvhvt_dlc_rotweak = .00e-9
+ lvt_dlc_rotweak = .00e-9
+ hv_dlc_rotweak = .00e-9
+ sky130_fd_pr__nfet_01v8__dlc_rotweak = lv_dlc_rotweak
+ sky130_fd_pr__esd_nfet_01v8__dlc_rotweak = lv_dlc_rotweak
+ sky130_fd_pr__nfet_01v8_lvt__dlc_rotweak = lvt_dlc_rotweak
+ sky130_fd_pr__pfet_01v8__dlc_rotweak = lv_dlc_rotweak
+ sky130_fd_pr__pfet_01v8_lvt__dlc_rotweak = lvt_dlc_rotweak
+ sky130_fd_pr__pfet_01v8_hvt__dlc_rotweak = lvhvt_dlc_rotweak
+ sky130_fd_pr__esd_nfet_g5v0d10v5__dlc_rotweak = hv_dlc_rotweak
+ sky130_fd_pr__esd_pfet_g5v0d10v5__dlc_rotweak = hv_dlc_rotweak
+ sky130_fd_pr__nfet_03v3_nvt__dlc_rotweak = hv_dlc_rotweak
+ sky130_fd_pr__nfet_05v0_nvt__dlc_rotweak = hv_dlc_rotweak
+ sky130_fd_pr__nfet_g5v0d10v5__dlc_rotweak = hv_dlc_rotweak
+ sky130_fd_pr__pfet_g5v0d10v5__dlc_rotweak = hv_dlc_rotweak
+ sky130_fd_pr__pfet_g5v0d16v0__dlc_rotweak = hv_dlc_rotweak
+ sky130_fd_pr__special_nfet_pass__dlc_rotweak = lv_dlc_rotweak
+ sky130_fd_pr__special_nfet_pass_lowleakage__dlc_rotweak = lv_dlc_rotweak
+ sky130_fd_pr__special_nfet_pass_flash__dlc_rotweak = hv_dlc_rotweak
+ sky130_fd_pr__special_nfet_latch__dlc_rotweak = lv_dlc_rotweak
+ sky130_fd_pr__special_nfet_latch_lowleakage__dlc_rotweak = lv_dlc_rotweak
+ sky130_fd_pr__special_pfet_latch__dlc_rotweak = lv_dlc_rotweak
+ sky130_fd_pr__special_pfet_latch_lowleakage__dlc_rotweak = lv_dlc_rotweak
+ sky130_fd_bs_flash__special_sonosfet_star__dlc_rotweak = hv_dlc_rotweak
+ sky130_fd_bs_flash__special_sonosfet_original__dlc_rotweak = hv_dlc_rotweak
+ sonos_eeol_dlc_rotweak = hv_dlc_rotweak
+ sonos_peol_dlc_rotweak = hv_dlc_rotweak

.temp 27
VDD vdd 0 1.8
VREF ref 0 1.2
VB0 b0 0 0
VB0bar b0bar 0 1.8
X0hn bit0 b0 ref 0 sky130_fd_pr__nfet_01v8 w=4 l=0.15
X0hp bit0 b0bar ref vdd sky130_fd_pr__pfet_01v8 w=8 l=0.15
X0ln bit0 b0bar 0 0 sky130_fd_pr__nfet_01v8 w=4 l=0.15
X0lp bit0 b0 0 vdd sky130_fd_pr__pfet_01v8 w=8 l=0.15
Rbranch0 n0 bit0 20000
Rseries0 n0 n1 10000
VB1 b1 0 0
VB1bar b1bar 0 1.8
X1hn bit1 b1 ref 0 sky130_fd_pr__nfet_01v8 w=4 l=0.15
X1hp bit1 b1bar ref vdd sky130_fd_pr__pfet_01v8 w=8 l=0.15
X1ln bit1 b1bar 0 0 sky130_fd_pr__nfet_01v8 w=4 l=0.15
X1lp bit1 b1 0 vdd sky130_fd_pr__pfet_01v8 w=8 l=0.15
Rbranch1 n1 bit1 20000
Rseries1 n1 n2 10000
VB2 b2 0 0
VB2bar b2bar 0 1.8
X2hn bit2 b2 ref 0 sky130_fd_pr__nfet_01v8 w=4 l=0.15
X2hp bit2 b2bar ref vdd sky130_fd_pr__pfet_01v8 w=8 l=0.15
X2ln bit2 b2bar 0 0 sky130_fd_pr__nfet_01v8 w=4 l=0.15
X2lp bit2 b2 0 vdd sky130_fd_pr__pfet_01v8 w=8 l=0.15
Rbranch2 n2 bit2 20000
Rseries2 n2 n3 10000
VB3 b3 0 0
VB3bar b3bar 0 1.8
X3hn bit3 b3 ref 0 sky130_fd_pr__nfet_01v8 w=4 l=0.15
X3hp bit3 b3bar ref vdd sky130_fd_pr__pfet_01v8 w=8 l=0.15
X3ln bit3 b3bar 0 0 sky130_fd_pr__nfet_01v8 w=4 l=0.15
X3lp bit3 b3 0 vdd sky130_fd_pr__pfet_01v8 w=8 l=0.15
Rbranch3 n3 bit3 20000
Rseries3 n3 n4 10000
VB4 b4 0 0
VB4bar b4bar 0 1.8
X4hn bit4 b4 ref 0 sky130_fd_pr__nfet_01v8 w=4 l=0.15
X4hp bit4 b4bar ref vdd sky130_fd_pr__pfet_01v8 w=8 l=0.15
X4ln bit4 b4bar 0 0 sky130_fd_pr__nfet_01v8 w=4 l=0.15
X4lp bit4 b4 0 vdd sky130_fd_pr__pfet_01v8 w=8 l=0.15
Rbranch4 n4 bit4 20000
Rseries4 n4 n5 10000
VB5 b5 0 0
VB5bar b5bar 0 1.8
X5hn bit5 b5 ref 0 sky130_fd_pr__nfet_01v8 w=4 l=0.15
X5hp bit5 b5bar ref vdd sky130_fd_pr__pfet_01v8 w=8 l=0.15
X5ln bit5 b5bar 0 0 sky130_fd_pr__nfet_01v8 w=4 l=0.15
X5lp bit5 b5 0 vdd sky130_fd_pr__pfet_01v8 w=8 l=0.15
Rbranch5 n5 bit5 20000
Rseries5 n5 n6 10000
VB6 b6 0 0
VB6bar b6bar 0 1.8
X6hn bit6 b6 ref 0 sky130_fd_pr__nfet_01v8 w=4 l=0.15
X6hp bit6 b6bar ref vdd sky130_fd_pr__pfet_01v8 w=8 l=0.15
X6ln bit6 b6bar 0 0 sky130_fd_pr__nfet_01v8 w=4 l=0.15
X6lp bit6 b6 0 vdd sky130_fd_pr__pfet_01v8 w=8 l=0.15
Rbranch6 n6 bit6 20000
Rseries6 n6 n7 10000
VB7 b7 0 0
VB7bar b7bar 0 1.8
X7hn bit7 b7 ref 0 sky130_fd_pr__nfet_01v8 w=4 l=0.15
X7hp bit7 b7bar ref vdd sky130_fd_pr__pfet_01v8 w=8 l=0.15
X7ln bit7 b7bar 0 0 sky130_fd_pr__nfet_01v8 w=4 l=0.15
X7lp bit7 b7 0 vdd sky130_fd_pr__pfet_01v8 w=8 l=0.15
Rbranch7 n7 bit7 20000
Rterminate n7 0 20000
Rload n0 0 1e+12
Cload n0 0 1e-13
.options reltol=1e-5 abstol=1e-14 vntol=1e-9
.control
set numdgt=15
alter VB0 = 0
alter VB0bar = 1.8
alter VB1 = 0
alter VB1bar = 1.8
alter VB2 = 0
alter VB2bar = 1.8
alter VB3 = 0
alter VB3bar = 1.8
alter VB4 = 0
alter VB4bar = 1.8
alter VB5 = 0
alter VB5bar = 1.8
alter VB6 = 0
alter VB6bar = 1.8
alter VB7 = 0
alter VB7bar = 1.8
op
echo REF_CODE_0
print v(n0) i(VREF) i(VDD)
alter VB0 = 0
alter VB0bar = 1.8
alter VB1 = 0
alter VB1bar = 1.8
alter VB2 = 0
alter VB2bar = 1.8
alter VB3 = 1.8
alter VB3bar = 0
alter VB4 = 1.8
alter VB4bar = 0
alter VB5 = 0
alter VB5bar = 1.8
alter VB6 = 1.8
alter VB6bar = 0
alter VB7 = 0
alter VB7bar = 1.8
op
echo REF_CODE_26
print v(n0) i(VREF) i(VDD)
alter VB0 = 0
alter VB0bar = 1.8
alter VB1 = 1.8
alter VB1bar = 0
alter VB2 = 1.8
alter VB2bar = 0
alter VB3 = 1.8
alter VB3bar = 0
alter VB4 = 1.8
alter VB4bar = 0
alter VB5 = 1.8
alter VB5bar = 0
alter VB6 = 1.8
alter VB6bar = 0
alter VB7 = 1.8
alter VB7bar = 0
op
echo REF_CODE_127
print v(n0) i(VREF) i(VDD)
alter VB0 = 1.8
alter VB0bar = 0
alter VB1 = 0
alter VB1bar = 1.8
alter VB2 = 0
alter VB2bar = 1.8
alter VB3 = 0
alter VB3bar = 1.8
alter VB4 = 0
alter VB4bar = 1.8
alter VB5 = 0
alter VB5bar = 1.8
alter VB6 = 0
alter VB6bar = 1.8
alter VB7 = 0
alter VB7bar = 1.8
op
echo REF_CODE_128
print v(n0) i(VREF) i(VDD)
alter VB0 = 1.8
alter VB0bar = 0
alter VB1 = 1.8
alter VB1bar = 0
alter VB2 = 1.8
alter VB2bar = 0
alter VB3 = 1.8
alter VB3bar = 0
alter VB4 = 1.8
alter VB4bar = 0
alter VB5 = 1.8
alter VB5bar = 0
alter VB6 = 1.8
alter VB6bar = 0
alter VB7 = 1.8
alter VB7bar = 0
op
echo REF_CODE_255
print v(n0) i(VREF) i(VDD)
quit
.endc
.end
