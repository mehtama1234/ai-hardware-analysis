* NGSPICE file created from sky130_isolated_frontend_active_load_latch_v2.ext - technology: sky130A

.subckt sky130_isolated_frontend_active_load_latch_v2 out_p out_n latch_sense_p latch_sense_n
+ tail reset vdd vss eval sense_p sense_n iso_tail vdd_active
X0 out_p out_n vdd_active vdd_active sky130_fd_pr__pfet_01v8 ad=3.36 pd=8 as=3.12 ps=7.6 w=1.2 l=0.6
X1 vdd reset out_n vdd sky130_fd_pr__pfet_01v8 ad=3.12 pd=7.6 as=3.36 ps=8 w=1.2 l=0.6
X2 tail out_p out_n vss sky130_fd_pr__nfet_01v8 ad=12.48 pd=14.8 as=13.44 ps=15.2 w=4.8 l=0.6
X3 out_p reset vdd vdd sky130_fd_pr__pfet_01v8 ad=3.36 pd=8 as=3.12 ps=7.6 w=1.2 l=0.6
X4 out_p out_n tail vss sky130_fd_pr__nfet_01v8 ad=13.44 pd=15.2 as=12.48 ps=14.8 w=4.8 l=0.6
X5 tail latch_sense_n out_n vss sky130_fd_pr__nfet_01v8 ad=12.48 pd=14.8 as=13.44 ps=15.2 w=4.8 l=0.6
X6 tail eval vss vss sky130_fd_pr__nfet_01v8 ad=16.2 pd=17.4 as=16.2 ps=17.4 w=6 l=0.6
X7 out_p latch_sense_p tail vss sky130_fd_pr__nfet_01v8 ad=13.44 pd=15.2 as=12.48 ps=14.8 w=4.8 l=0.6
X8 iso_tail sense_n latch_sense_n vss sky130_fd_pr__nfet_01v8 ad=3.12 pd=7.6 as=3.36 ps=8 w=1.2 l=0.6
X9 vdd_active out_p out_n vdd_active sky130_fd_pr__pfet_01v8 ad=3.12 pd=7.6 as=3.36 ps=8 w=1.2 l=0.6
X10 latch_sense_p sense_p iso_tail vss sky130_fd_pr__nfet_01v8 ad=3.36 pd=8 as=3.12 ps=7.6 w=1.2 l=0.6
C0 vdd tail 0.9918f
C1 out_n vdd 0.77104f
C2 tail latch_sense_n 0.0334f
C3 out_n latch_sense_n 0.1874f
C4 reset vdd 4.47121f
C5 iso_tail sense_p 0.26105f
C6 sense_n latch_sense_n 0.22977f
C7 out_n tail 0.51868f
C8 vdd_active tail 0.9938f
C9 eval tail 0.35666f
C10 out_n vdd_active 3.16716f
C11 reset tail 0.16491f
C12 reset out_n 0.31048f
C13 latch_sense_p tail 0.0334f
C14 iso_tail latch_sense_n 0.20888f
C15 out_p vdd 0.76206f
C16 out_p tail 0.51868f
C17 out_p out_n 2.58376f
C18 out_p vdd_active 3.06556f
C19 latch_sense_p sense_p 0.22977f
C20 iso_tail latch_sense_p 0.20888f
C21 sense_n iso_tail 0.10725f
C22 out_p reset 0.376f
C23 latch_sense_p out_p 0.1874f
C24 iso_tail vss 25.9007f
C25 sense_n vss 3.5386f
C26 sense_p vss 3.13592f
C27 latch_sense_n vss 10.0606f
C28 latch_sense_p vss 10.0606f
C29 out_n vss 22.2843f
C30 out_p vss 22.3137f
C31 reset vss 9.61412f
C32 tail vss 46.3898f
C33 eval vss 5.80878f
C34 vdd_active vss 70.2559f
C35 vdd vss 73.848f
.ends
