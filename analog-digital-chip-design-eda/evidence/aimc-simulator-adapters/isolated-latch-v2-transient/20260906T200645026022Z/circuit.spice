* NGSPICE file created from sky130_isolated_frontend_active_load_latch_v2.ext - technology: sky130A

.subckt sky130_isolated_frontend_active_load_latch_v2 out_p out_n latch_sense_p latch_sense_n
+ tail reset vdd vss eval sense_p sense_n iso_tail vdd_active
X0 latch_sense_p sense_p iso_tail vss sky130_fd_pr__nfet_01v8 ad=3.36 pd=8 as=3.12 ps=7.6 w=1.2 l=0.6
X1 out_p out_n tail vss sky130_fd_pr__nfet_01v8 ad=3.36 pd=8 as=3.12 ps=7.6 w=1.2 l=0.6
X2 out_n latch_sense_n tail vss sky130_fd_pr__nfet_01v8 ad=3.36 pd=8 as=3.12 ps=7.6 w=1.2 l=0.6
X3 out_n out_p vdd_active vdd_active sky130_fd_pr__pfet_01v8 ad=3.36 pd=8 as=3.12 ps=7.6 w=1.2 l=0.6
X4 iso_tail sense_n latch_sense_n vss sky130_fd_pr__nfet_01v8 ad=3.12 pd=7.6 as=3.36 ps=8 w=1.2 l=0.6
X5 out_n out_p tail vss sky130_fd_pr__nfet_01v8 ad=3.36 pd=8 as=3.12 ps=7.6 w=1.2 l=0.6
X6 out_n reset vdd vdd sky130_fd_pr__pfet_01v8 ad=3.36 pd=8 as=3.12 ps=7.6 w=1.2 l=0.6
X7 out_p latch_sense_p tail vss sky130_fd_pr__nfet_01v8 ad=3.36 pd=8 as=3.12 ps=7.6 w=1.2 l=0.6
X8 tail eval vss vss sky130_fd_pr__nfet_01v8 ad=16.8 pd=17.6 as=15.6 ps=17.2 w=6 l=0.6
X9 out_p out_n vdd_active vdd_active sky130_fd_pr__pfet_01v8 ad=3.36 pd=8 as=3.12 ps=7.6 w=1.2 l=0.6
X10 out_p reset vdd vdd sky130_fd_pr__pfet_01v8 ad=3.36 pd=8 as=3.12 ps=7.6 w=1.2 l=0.6
CSYM0 eval out_n 0.0318f
CSYM1 eval out_p 0.0318f
CSYM2 eval tail 0.09415f
CSYM3 eval vss 1.1758f
CSYM4 iso_tail latch_sense_n 0.12463f
CSYM5 iso_tail latch_sense_p 0.12463f
CSYM6 iso_tail m1_1000_12500# 0.00302f
CSYM7 iso_tail m1_3440_12500# 0.00302f
CSYM8 iso_tail sense_n 0.117355f
CSYM9 iso_tail sense_p 0.117355f
CSYM10 iso_tail vss 2.81735f
CSYM11 latch_sense_n latch_sense_p 0.0207f
CSYM12 latch_sense_n m1_3440_12500# 0.03083f
CSYM13 latch_sense_n out_n 0.685415f
CSYM14 latch_sense_n out_p 0.635635f
CSYM15 latch_sense_n sense_n 0.05996f
CSYM16 latch_sense_n tail 0.398265f
CSYM17 latch_sense_n vdd_active 0.51921f
CSYM18 latch_sense_n vss 8.19846f
CSYM19 latch_sense_p m1_1000_12500# 0.03083f
CSYM20 latch_sense_p out_n 0.635635f
CSYM21 latch_sense_p out_p 0.685415f
CSYM22 latch_sense_p sense_p 0.05996f
CSYM23 latch_sense_p tail 0.398265f
CSYM24 latch_sense_p vdd_active 0.51921f
CSYM25 latch_sense_p vss 8.19846f
CSYM26 m1_1000_12500# sense_p 0.04904f
CSYM27 m1_1000_12500# vss 0.33861f
CSYM28 m1_3440_12500# sense_n 0.04904f
CSYM29 m1_3440_12500# vss 0.33861f
CSYM30 out_n out_p 1.85382f
CSYM31 out_n reset 0.06791f
CSYM32 out_n tail 2.807965f
CSYM33 out_n vdd 1.00284f
CSYM34 out_n vdd_active 4.922095f
CSYM35 out_n vss 15.717f
CSYM36 out_p reset 0.06791f
CSYM37 out_p tail 2.807965f
CSYM38 out_p vdd 1.00284f
CSYM39 out_p vdd_active 4.922095f
CSYM40 out_p vss 15.717f
CSYM41 reset vdd 4.28849f
CSYM42 reset vss 0.8786f
CSYM43 sense_n vss 1.42522f
CSYM44 sense_p vss 1.42522f
CSYM45 tail vss 10.0187f
CSYM46 vdd vss 30.6807f
CSYM47 vdd_active vss 45.577f
.ends
