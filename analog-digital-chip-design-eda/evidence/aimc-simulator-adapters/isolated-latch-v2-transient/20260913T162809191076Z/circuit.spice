* NGSPICE file created from sky130_isolated_frontend_active_load_latch_v2.ext - technology: sky130A

.subckt sky130_isolated_frontend_active_load_latch_v2 out_p out_n latch_sense_p latch_sense_n
+ tail reset vdd vss eval sense_p sense_n iso_tail vdd_active
X0 out_p out_n vdd_active vdd_active sky130_fd_pr__pfet_01v8 ad=3.36 pd=8 as=3.12 ps=7.6 w=1.2 l=0.6
X1 vdd reset out_n vdd sky130_fd_pr__pfet_01v8 ad=3.12 pd=7.6 as=3.36 ps=8 w=1.2 l=0.6
X2 tail out_p out_n vss sky130_fd_pr__nfet_01v8 ad=6.24 pd=10 as=6.72 ps=10.4 w=2.4 l=0.6
X3 out_p reset vdd vdd sky130_fd_pr__pfet_01v8 ad=3.36 pd=8 as=3.12 ps=7.6 w=1.2 l=0.6
X4 out_p out_n tail vss sky130_fd_pr__nfet_01v8 ad=6.72 pd=10.4 as=6.24 ps=10 w=2.4 l=0.6
X5 tail latch_sense_n out_n vss sky130_fd_pr__nfet_01v8 ad=6.24 pd=10 as=6.72 ps=10.4 w=2.4 l=0.6
X6 tail eval vss vss sky130_fd_pr__nfet_01v8 ad=16.2 pd=17.4 as=16.2 ps=17.4 w=6 l=0.6
X7 out_p latch_sense_p tail vss sky130_fd_pr__nfet_01v8 ad=6.72 pd=10.4 as=6.24 ps=10 w=2.4 l=0.6
X8 iso_tail sense_n latch_sense_n vss sky130_fd_pr__nfet_01v8 ad=3.12 pd=7.6 as=3.36 ps=8 w=1.2 l=0.6
X9 vdd_active out_p out_n vdd_active sky130_fd_pr__pfet_01v8 ad=3.12 pd=7.6 as=3.36 ps=8 w=1.2 l=0.6
X10 latch_sense_p sense_p iso_tail vss sky130_fd_pr__nfet_01v8 ad=3.36 pd=8 as=3.12 ps=7.6 w=1.2 l=0.6
CSYM0 eval tail 0.35666f
CSYM1 eval vss 5.80878f
CSYM2 iso_tail latch_sense_n 0.20888f
CSYM3 iso_tail latch_sense_p 0.20888f
CSYM4 iso_tail sense_n 0.18415f
CSYM5 iso_tail sense_p 0.18415f
CSYM6 iso_tail vss 25.9007f
CSYM7 latch_sense_n out_n 0.1882f
CSYM8 latch_sense_n sense_n 0.22977f
CSYM9 latch_sense_n tail 0.0334f
CSYM10 latch_sense_n vss 10.483f
CSYM11 latch_sense_p out_p 0.1882f
CSYM12 latch_sense_p sense_p 0.22977f
CSYM13 latch_sense_p tail 0.0334f
CSYM14 latch_sense_p vss 10.483f
CSYM15 out_n out_p 2.56057f
CSYM16 out_n reset 0.34324f
CSYM17 out_n tail 0.48331f
CSYM18 out_n vdd 0.76655f
CSYM19 out_n vdd_active 3.11636f
CSYM20 out_n vss 22.90585f
CSYM21 out_p reset 0.34324f
CSYM22 out_p tail 0.48331f
CSYM23 out_p vdd 0.76655f
CSYM24 out_p vdd_active 3.11636f
CSYM25 out_p vss 22.90585f
CSYM26 reset tail 0.16491f
CSYM27 reset vdd 4.47121f
CSYM28 reset vss 9.61412f
CSYM29 sense_n vss 3.33726f
CSYM30 sense_p vss 3.33726f
CSYM31 tail vdd 0.9918f
CSYM32 tail vdd_active 0.9938f
CSYM33 tail vss 46.6146f
CSYM34 vdd vss 73.848f
CSYM35 vdd_active vss 70.2559f
.ends
