* Signed small-signal extracted latch diagnostic, no structural MOS substitution.
.lib "/home/mehtama1/eda-tools/pdks/sky130A/libs.tech/ngspice/sky130.lib.spice" tt
.include "/home/mehtama1/git-repo/ai-hardware-analysis/analog-digital-chip-design-eda/evidence/aimc-simulator-adapters/isolated-latch-v2-transient/20260906T193418176879Z/extracted.spice"
.temp 27
.options method=gear reltol=1e-4 abstol=1e-14 vntol=1e-7
VDD vdd 0 1.8
VACTIVE vdd_active 0 1.8
VSS vss 0 0
VP sense_p 0 0.90025
VN sense_n 0 0.89975
IBIAS iso_tail 0 4u
RP vdd latch_sense_p 100k
RN vdd latch_sense_n 100k
VRESET reset 0 PULSE(0 1.8 8n 20p 20p 30n 50n)
VEVAL eval 0 PULSE(0 1.8 8.2n 20p 20p 30n 50n)
XU out_p out_n latch_sense_p latch_sense_n tail reset vdd vss eval sense_p sense_n iso_tail vdd_active sky130_isolated_frontend_active_load_latch_v2
.tran 20p 20n
.measure tran op_final FIND v(out_p) AT=18n
.measure tran on_final FIND v(out_n) AT=18n
.measure tran lp_before FIND v(latch_sense_p) AT=7.8n
.measure tran ln_before FIND v(latch_sense_n) AT=7.8n
.control
run
write waveform.raw v(out_p) v(out_n) v(latch_sense_p) v(latch_sense_n) v(iso_tail) v(tail) v(reset) v(eval) i(VDD) i(VACTIVE)
.endc
.end
