* NGSPICE file created from aimc_converter_macro_active_candidate_flat.ext - technology: sky130A

.subckt aimc_converter_macro_active_candidate_flat vss vdd row_drive sar_comparator_input
+ decision_p decision_n reset eval vss_escape latch_sense_p_ext latch_sense_n_ext
+ iso_tail_ext tail_ext vdd_ext
X0 physical_preamp_n.drain physical_preamp_n.gate physical_preamp_n.source vss_escape sky130_fd_pr__nfet_01v8 ad=3.36 pd=8 as=3.12 ps=7.6 w=1.2 l=0.6
X1 vdd_ext decision_p decision_n vdd_ext sky130_fd_pr__pfet_01v8 ad=3.12 pd=7.6 as=3.36 ps=8 w=1.2 l=0.6
X2 tail_ext eval vss_escape vss_escape sky130_fd_pr__nfet_01v8 ad=16.2 pd=17.4 as=16.2 ps=17.4 w=6 l=0.6
X3 decision_p latch_sense_p_ext tail_ext vss_escape sky130_fd_pr__nfet_01v8 ad=3.36 pd=8 as=3.12 ps=7.6 w=1.2 l=0.6
X4 vdd_ext reset decision_n vdd_ext sky130_fd_pr__pfet_01v8 ad=3.12 pd=7.6 as=3.36 ps=8 w=1.2 l=0.6
X5 tail_ext latch_sense_n_ext decision_n vss_escape sky130_fd_pr__nfet_01v8 ad=3.12 pd=7.6 as=3.36 ps=8 w=1.2 l=0.6
X6 decision_p decision_n vdd_ext vdd_ext sky130_fd_pr__pfet_01v8 ad=3.36 pd=8 as=3.12 ps=7.6 w=1.2 l=0.6
X7 tail_ext decision_p decision_n vss_escape sky130_fd_pr__nfet_01v8 ad=3.12 pd=7.6 as=3.36 ps=8 w=1.2 l=0.6
X8 latch_sense_p_ext row_drive iso_tail_ext vss_escape sky130_fd_pr__nfet_01v8 ad=3.36 pd=8 as=3.12 ps=7.6 w=1.2 l=0.6
X9 iso_tail_ext sar_comparator_input latch_sense_n_ext vss_escape sky130_fd_pr__nfet_01v8 ad=3.12 pd=7.6 as=3.36 ps=8 w=1.2 l=0.6
X10 physical_preamp_p.drain physical_preamp_p.gate physical_preamp_p.source vss_escape sky130_fd_pr__nfet_01v8 ad=3.36 pd=8 as=3.12 ps=7.6 w=1.2 l=0.6
X11 decision_p reset vdd_ext vdd_ext sky130_fd_pr__pfet_01v8 ad=3.36 pd=8 as=3.12 ps=7.6 w=1.2 l=0.6
X12 decision_p decision_n tail_ext vss_escape sky130_fd_pr__nfet_01v8 ad=3.36 pd=8 as=3.12 ps=7.6 w=1.2 l=0.6
C0 sar_comparator_input latch_sense_p_ext 1.32953f
C1 row_drive decision_p 0.02173f
C2 shared_converter_mux_0.mux_bus vss 0.03132f
C3 physical_preamp_n.drain physical_preamp_n.gate 0.02459f
C4 shared_converter_mux_0.vdd vdd_ext 0
C5 latch_sense_p_ext latch_sense_n_ext 0.04014f
C6 latch_sense_p_ext vdd_ext 3.83973f
C7 row_dac_10b_0.vss row_dac_10b_0.vdd 0.78467f
C8 decision_n decision_p 2.54301f
C9 sar_comparator_input latch_sense_n_ext 0.38203f
C10 reset vdd_ext 4.48789f
C11 tail_ext decision_p 0.48065f
C12 sar_comparator_input vdd_ext 1.56594f
C13 shared_converter_mux_0.vdd vss 0.2816f
C14 latch_sense_p_ext vss 0.32714f
C15 row_drive sar_readout_12b_0.vdd 0.58157f
C16 latch_sense_n_ext vdd_ext 3.48574f
C17 sar_readout_12b_0.vss iso_tail_ext 0.60045f
C18 shared_converter_mux_0.vss shared_converter_mux_0.mux_bus 1.56188f
C19 vdd row_drive 0.1964f
C20 sar_comparator_input vss 0.09437f
C21 iso_tail_ext latch_sense_p_ext 0.12577f
C22 vss latch_sense_n_ext 0.23329f
C23 row_drive tail_ext 0.04474f
C24 physical_preamp_n.gate physical_preamp_n.source 0.02892f
C25 vss vdd_ext 0.19458f
C26 physical_preamp_n.drain vdd_ext 0.00868f
C27 physical_preamp_p.gate vdd_ext 0.02013f
C28 latch_sense_p_ext decision_p 0.18428f
C29 iso_tail_ext sar_comparator_input 0.16721f
C30 shared_converter_mux_0.mux_bus row_drive 0.06281f
C31 decision_n tail_ext 0.48065f
C32 iso_tail_ext latch_sense_n_ext 0.12577f
C33 row_dac_10b_0.vss row_drive 1.08123f
C34 reset decision_p 0.376f
C35 sar_readout_12b_0.vss sar_readout_12b_0.vdd 0.49712f
C36 sar_readout_12b_0.vss row_drive 0.29433f
C37 iso_tail_ext vdd_ext 0.86179f
C38 row_drive m1_68300_3080# 2.68328f
C39 eval tail_ext 0.36751f
C40 shared_converter_mux_0.vss vdd_ext 0
C41 decision_p vdd_ext 3.8282f
C42 shared_converter_mux_0.vdd row_drive 0.00246f
C43 latch_sense_p_ext row_drive 1.86012f
C44 physical_preamp_p.source vdd_ext 0.0083f
C45 physical_preamp_p.drain vdd_ext 0.00868f
C46 physical_preamp_n.source vdd_ext 0.0083f
C47 sar_comparator_input row_drive 5.41305f
C48 row_drive latch_sense_n_ext 0.57894f
C49 latch_sense_p_ext tail_ext 0.0334f
C50 physical_preamp_p.gate physical_preamp_p.source 0.02892f
C51 physical_preamp_p.gate physical_preamp_p.drain 0.02459f
C52 sar_readout_12b_0.vdd vdd_ext 1.39936f
C53 row_drive vdd_ext 4.04838f
C54 reset decision_n 0.31048f
C55 physical_preamp_n.drain physical_preamp_n.source 0.03982f
C56 sar_comparator_input decision_n 0.27273f
C57 reset tail_ext 0.17577f
C58 shared_converter_mux_0.mux_bus shared_converter_mux_0.vdd 1.55306f
C59 sar_comparator_input tail_ext 0.21605f
C60 decision_n latch_sense_n_ext 0.18428f
C61 vss row_drive 0.44137f
C62 latch_sense_n_ext tail_ext 0.0334f
C63 decision_n vdd_ext 3.9382f
C64 tail_ext vdd_ext 1.9856f
C65 row_dac_10b_0.vdd row_drive 1.11462f
C66 eval vdd_ext 0
C67 physical_preamp_p.source physical_preamp_p.drain 0.03982f
C68 physical_preamp_n.gate vdd_ext 0.02013f
C69 sar_comparator_input m1_68300_3080# 0.05195f
C70 shared_converter_mux_0.mux_bus vdd_ext 0.00217f
C71 iso_tail_ext sar_readout_12b_0.vdd 0.27521f
C72 iso_tail_ext row_drive 2.39704f
C73 sar_readout_12b_0.vss vdd_ext 0.93663f
C74 shared_converter_mux_0.vss row_drive 0.00246f
C75 m1_68300_3080# vdd_ext 0.24419f
C76 vss vss_escape 36.2336f
C77 vdd vss_escape 36.7f
C78 iso_tail_ext vss_escape 75.2611f
C79 latch_sense_n_ext vss_escape 14.9559f
C80 latch_sense_p_ext vss_escape 39.337f
C81 decision_p vss_escape 8.36234f
C82 tail_ext vss_escape 87.91016f
C83 vdd_ext vss_escape 0.25711p
C84 sar_readout_12b_0.vss vss_escape 1.33686f ; **FLOATING
C85 row_dac_10b_0.vss vss_escape 1.40333f ; **FLOATING
C86 row_dac_10b_0.vdd vss_escape 1.33457f ; **FLOATING
C87 sar_readout_12b_0.vdd vss_escape 1.77614f ; **FLOATING
C88 m1_68300_3080# vss_escape 7.89552f ; **FLOATING
C89 shared_converter_mux_0.vss vss_escape 1.39454f ; **FLOATING
C90 shared_converter_mux_0.mux_bus vss_escape 2.86922f ; **FLOATING
C91 shared_converter_mux_0.vdd vss_escape 0.95985f ; **FLOATING
C92 physical_preamp_n.drain vss_escape 1.37396f
C93 physical_preamp_n.source vss_escape 1.3736f
C94 physical_preamp_p.drain vss_escape 1.37396f
C95 physical_preamp_p.source vss_escape 1.3736f
.ends
