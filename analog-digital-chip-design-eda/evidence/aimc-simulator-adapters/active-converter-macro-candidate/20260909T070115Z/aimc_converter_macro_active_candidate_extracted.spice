* NGSPICE file created from aimc_converter_macro_active_candidate.ext - technology: sky130A

.subckt sky130_transistor_active_isolation_pair iso_tail iso_p iso_n sense_p sense_n
+ m1_3440_500# m1_1000_500# m2_900_1400# VSUBS
X0 iso_tail sense_n iso_n VSUBS sky130_fd_pr__nfet_01v8 ad=3.12 pd=7.6 as=3.36 ps=8 w=1.2 l=0.6
X1 iso_p sense_p iso_tail VSUBS sky130_fd_pr__nfet_01v8 ad=3.36 pd=8 as=3.12 ps=7.6 w=1.2 l=0.6
C0 sense_p m1_1000_500# 0.04555f
C1 iso_p m1_1000_500# 0.0015f
C2 iso_tail m1_1000_500# 0.0015f
C3 m2_900_1400# m1_1000_500# 0.01113f
C4 sense_p iso_p 0.02157f
C5 sense_p iso_tail 0.12292f
C6 iso_n iso_p 0.00782f
C7 iso_p iso_tail 0.05749f
C8 iso_n iso_tail 0.05717f
C9 iso_n sense_n 0.02157f
C10 iso_n m1_3440_500# 0.0015f
C11 sense_n iso_tail 0.11179f
C12 m1_3440_500# iso_tail 0.0015f
C13 m2_900_1400# sense_p 0.04273f
C14 m1_3440_500# sense_n 0.04555f
C15 m2_900_1400# iso_p 0.41846f
C16 iso_n m2_900_1400# 0.41846f
C17 m2_900_1400# iso_tail 0.34398f
C18 m2_900_1400# sense_n 0.04273f
C19 m1_3440_500# m2_900_1400# 0.01113f
C20 iso_n VSUBS 1.04634f
C21 iso_p VSUBS 1.04634f
C22 iso_tail VSUBS 4.24257f
C23 m2_900_1400# VSUBS 1.01648f
C24 m1_3440_500# VSUBS 0.31893f
C25 m1_1000_500# VSUBS 0.31893f
.ends

.subckt escaped_input_latch out_p out_n latch_sense_p latch_sense_n tail reset vdd
+ vss eval sense_p sense_n iso_tail vdd_active
X0 out_p out_n vdd_active vdd_active sky130_fd_pr__pfet_01v8 ad=3.36 pd=8 as=3.12 ps=7.6 w=1.2 l=0.6
X1 vdd reset out_n vdd sky130_fd_pr__pfet_01v8 ad=3.12 pd=7.6 as=3.36 ps=8 w=1.2 l=0.6
X2 tail out_p out_n vss sky130_fd_pr__nfet_01v8 ad=3.12 pd=7.6 as=3.36 ps=8 w=1.2 l=0.6
X3 out_p reset vdd vdd sky130_fd_pr__pfet_01v8 ad=3.36 pd=8 as=3.12 ps=7.6 w=1.2 l=0.6
X4 out_p out_n tail vss sky130_fd_pr__nfet_01v8 ad=3.36 pd=8 as=3.12 ps=7.6 w=1.2 l=0.6
X5 tail latch_sense_n out_n vss sky130_fd_pr__nfet_01v8 ad=3.12 pd=7.6 as=3.36 ps=8 w=1.2 l=0.6
X6 tail eval vss vss sky130_fd_pr__nfet_01v8 ad=16.2 pd=17.4 as=16.2 ps=17.4 w=6 l=0.6
X7 out_p latch_sense_p tail vss sky130_fd_pr__nfet_01v8 ad=3.36 pd=8 as=3.12 ps=7.6 w=1.2 l=0.6
X8 iso_tail sense_n latch_sense_n vss sky130_fd_pr__nfet_01v8 ad=3.12 pd=7.6 as=3.36 ps=8 w=1.2 l=0.6
X9 vdd_active out_p out_n vdd_active sky130_fd_pr__pfet_01v8 ad=3.12 pd=7.6 as=3.36 ps=8 w=1.2 l=0.6
X10 latch_sense_p sense_p iso_tail vss sky130_fd_pr__nfet_01v8 ad=3.36 pd=8 as=3.12 ps=7.6 w=1.2 l=0.6
C0 sense_n iso_tail 0.10725f
C1 sense_n latch_sense_n 0.22977f
C2 vdd_active out_n 3.16716f
C3 reset out_n 0.31048f
C4 latch_sense_p iso_tail 0.20888f
C5 out_p out_n 2.54301f
C6 tail out_n 0.46979f
C7 latch_sense_n tail 0.0334f
C8 vdd out_n 0.77104f
C9 out_p vdd_active 3.06556f
C10 out_p latch_sense_p 0.18428f
C11 vdd_active tail 0.9938f
C12 sense_p iso_tail 0.26105f
C13 out_p reset 0.376f
C14 latch_sense_p tail 0.0334f
C15 reset tail 0.16491f
C16 out_p tail 0.46979f
C17 eval tail 0.35666f
C18 vdd reset 4.47121f
C19 out_p vdd 0.76206f
C20 sense_p latch_sense_p 0.22977f
C21 vdd tail 0.9918f
C22 latch_sense_n out_n 0.18428f
C23 latch_sense_n iso_tail 0.20888f
C24 iso_tail vss 29.23796f
C25 latch_sense_n vss 1.7693f
C26 latch_sense_p vss 1.56796f
C27 out_n vss 13.58747f
C28 tail vss 89.03816f
C29 vdd_active vss 90.11912f
C30 vdd vss 78.65506f
.ends

.subckt aimc_converter_macro_active_candidate vss vdd vdd_ext decision_p decision_n
+ reset eval vss_escape latch_sense_p_ext latch_sense_n_ext tail_ext
Xphysical_preamp_0 physical_preamp_0/iso_tail physical_preamp_0/iso_p physical_preamp_0/iso_n
+ physical_preamp_0/sense_p physical_preamp_0/sense_n physical_preamp_0/m1_3440_500#
+ vdd_ext physical_preamp_0/m2_900_1400# vss_escape sky130_transistor_active_isolation_pair
Xconverter_latch_0 decision_p decision_n latch_sense_p_ext latch_sense_n_ext tail_ext
+ reset vdd_ext vss_escape eval vdd_ext vdd_ext vdd_ext vdd_ext escaped_input_latch
C0 physical_preamp_0/m1_3440_500# physical_preamp_0/m2_900_1400# -0.00349f
C1 vdd_ext physical_preamp_0/iso_p 0.027f
C2 vdd_ext physical_preamp_0/sense_n 0.01014f
C3 physical_preamp_0/iso_n physical_preamp_0/m2_900_1400# -0
C4 shared_converter_mux_0/mux_bus shared_converter_mux_0/vdd 1.55306f
C5 physical_preamp_0/iso_n physical_preamp_0/m1_3440_500# -0
C6 vdd_ext row_dac_10b_0/vss 1.08123f
C7 tail_ext decision_p 0.01085f
C8 vdd_ext shared_converter_mux_0/vdd 0.00313f
C9 shared_converter_mux_0/mux_bus vss 0.03132f
C10 eval tail_ext 0.01085f
C11 shared_converter_mux_0/mux_bus shared_converter_mux_0/vss 1.56188f
C12 physical_preamp_0/iso_p physical_preamp_0/m2_900_1400# 0
C13 vdd_ext vss 0.41904f
C14 vdd_ext shared_converter_mux_0/vss 0.00313f
C15 row_dac_10b_0/vdd row_dac_10b_0/vss 0.78467f
C16 tail_ext decision_n 0.01085f
C17 vdd_ext vdd 0.1964f
C18 latch_sense_p_ext vss 0.23329f
C19 latch_sense_n_ext vss 0.23329f
C20 tail_ext reset 0.01085f
C21 vdd_ext shared_converter_mux_0/mux_bus 0.06497f
C22 vdd_ext physical_preamp_0/sense_p 0.03727f
C23 vdd_ext latch_sense_p_ext 0.07146f
C24 latch_sense_n_ext vdd_ext 0.07146f
C25 vdd_ext decision_p 0
C26 eval vdd_ext 0
C27 vdd_ext row_dac_10b_0/vdd 1.11409f
C28 physical_preamp_0/iso_tail vdd_ext 0.03755f
C29 vdd_ext physical_preamp_0/m2_900_1400# 0.15578f
C30 physical_preamp_0/sense_p physical_preamp_0/m2_900_1400# -0.00637f
C31 vdd_ext physical_preamp_0/m1_3440_500# 0.00852f
C32 vdd_ext physical_preamp_0/iso_n 0.02717f
C33 shared_converter_mux_0/vdd vss 0.2816f
C34 vdd_ext reset 0.01669f
C35 vss vss_escape 36.7f
C36 vdd vss_escape 36.7f
C37 latch_sense_n_ext vss_escape -0.04499f
C38 latch_sense_p_ext vss_escape -0.05647f
C39 decision_n vss_escape 3.8093f
C40 eval vss_escape 0.78348f
C41 vdd_ext vss_escape 63.23984f
.ends
