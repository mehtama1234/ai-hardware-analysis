* NGSPICE file created from aimc_converter_macro_active_candidate_flat.ext - technology: sky130A

.subckt aimc_converter_macro_active_candidate_flat vss vdd row_drive sar_comparator_input
+ decision_p decision_n reset eval vss_escape iso_tail_ext tail_ext vdd_ext latch_sense_p_ext_uq1
X0 physical_preamp_n.latch_sense_n_ext physical_preamp_n.sar_comparator_input latch_sense_p_ext_uq1 vss_escape sky130_fd_pr__nfet_01v8 ad=3.36 pd=8 as=3.12 ps=7.6 w=1.2 l=0.6
X1 vdd_ext decision_p decision_n vdd_ext sky130_fd_pr__pfet_01v8 ad=3.12 pd=7.6 as=3.36 ps=8 w=1.2 l=0.6
X2 tail_ext eval vss_escape vss_escape sky130_fd_pr__nfet_01v8 ad=16.2 pd=17.4 as=16.2 ps=17.4 w=6 l=0.6
X3 decision_p latch_sense_p_ext_uq1 tail_ext vss_escape sky130_fd_pr__nfet_01v8 ad=3.36 pd=8 as=3.12 ps=7.6 w=1.2 l=0.6
X4 vdd_ext reset decision_n vdd_ext sky130_fd_pr__pfet_01v8 ad=3.12 pd=7.6 as=3.36 ps=8 w=1.2 l=0.6
X5 tail_ext latch_sense_p_ext_uq1 decision_n vss_escape sky130_fd_pr__nfet_01v8 ad=3.12 pd=7.6 as=3.36 ps=8 w=1.2 l=0.6
X6 decision_p decision_n vdd_ext vdd_ext sky130_fd_pr__pfet_01v8 ad=3.36 pd=8 as=3.12 ps=7.6 w=1.2 l=0.6
X7 tail_ext decision_p decision_n vss_escape sky130_fd_pr__nfet_01v8 ad=3.12 pd=7.6 as=3.36 ps=8 w=1.2 l=0.6
X8 latch_sense_p_ext_uq1 row_drive iso_tail_ext vss_escape sky130_fd_pr__nfet_01v8 ad=3.36 pd=8 as=3.12 ps=7.6 w=1.2 l=0.6
X9 iso_tail_ext sar_comparator_input latch_sense_p_ext_uq1 vss_escape sky130_fd_pr__nfet_01v8 ad=3.12 pd=7.6 as=3.36 ps=8 w=1.2 l=0.6
X10 latch_sense_p_ext_uq1 row_drive latch_sense_p_ext_uq1 vss_escape sky130_fd_pr__nfet_01v8 ad=3.12 pd=7.6 as=16.32 ps=39.2 w=1.2 l=0.6
X11 decision_p reset vdd_ext vdd_ext sky130_fd_pr__pfet_01v8 ad=3.36 pd=8 as=3.12 ps=7.6 w=1.2 l=0.6
X12 decision_p decision_n tail_ext vss_escape sky130_fd_pr__nfet_01v8 ad=3.36 pd=8 as=3.12 ps=7.6 w=1.2 l=0.6
C0 shared_converter_mux_0.vdd vdd_ext 0
C1 shared_converter_mux_0.mux_bus vdd_ext 0.00217f
C2 decision_p reset 0.376f
C3 vss shared_converter_mux_0.vdd 0.2816f
C4 shared_converter_mux_0.vss vdd_ext 0
C5 vss shared_converter_mux_0.mux_bus 0.03132f
C6 latch_sense_p_ext_uq1 row_drive 2.12718f
C7 decision_n tail_ext 0.48065f
C8 iso_tail_ext sar_comparator_input 0.16721f
C9 iso_tail_ext sar_readout_12b_0.vss 0.60045f
C10 row_drive vdd_ext 3.83977f
C11 iso_tail_ext sar_readout_12b_0.vdd 0.27521f
C12 tail_ext latch_sense_p_ext_uq1 2.0919f
C13 sar_readout_12b_0.vss sar_readout_12b_0.vdd 0.49712f
C14 vss row_drive 0.22445f
C15 tail_ext vdd_ext 1.9856f
C16 physical_preamp_n.sar_comparator_input row_drive 0.12269f
C17 iso_tail_ext latch_sense_p_ext_uq1 0.25949f
C18 row_dac_10b_0.vss row_dac_10b_0.vdd 0.78467f
C19 latch_sense_p_ext_uq1 physical_preamp_n.latch_sense_n_ext 0.13155f
C20 row_dac_10b_0.vss row_drive 1.08123f
C21 tail_ext reset 0.17577f
C22 latch_sense_p_ext_uq1 sar_comparator_input 0.04367f
C23 shared_converter_mux_0.vdd shared_converter_mux_0.mux_bus 1.55306f
C24 iso_tail_ext vdd_ext 0.86179f
C25 physical_preamp_n.latch_sense_n_ext vdd_ext 0.01216f
C26 m4_45060_36440# latch_sense_p_ext_uq1 0.052f
C27 sar_comparator_input vdd_ext 1.06679f
C28 sar_readout_12b_0.vss vdd_ext 0.93663f
C29 m4_45060_36440# vdd_ext 0.01404f
C30 shared_converter_mux_0.mux_bus shared_converter_mux_0.vss 1.56188f
C31 sar_readout_12b_0.vdd vdd_ext 1.39936f
C32 m1_68300_3080# row_drive 2.68328f
C33 tail_ext eval 0.36751f
C34 decision_n latch_sense_p_ext_uq1 0.37635f
C35 shared_converter_mux_0.vdd row_drive 0.00246f
C36 tail_ext decision_p 0.48065f
C37 shared_converter_mux_0.mux_bus row_drive 0.06281f
C38 physical_preamp_n.sar_comparator_input physical_preamp_n.latch_sense_n_ext 0.08798f
C39 decision_n vdd_ext 3.9382f
C40 row_drive shared_converter_mux_0.vss 0.00246f
C41 latch_sense_p_ext_uq1 vdd_ext 10.0883f
C42 m4_51060_36440# latch_sense_p_ext_uq1 0.00822f
C43 row_drive row_dac_10b_0.vdd 1.11462f
C44 m4_51060_36440# vdd_ext 0.01404f
C45 latch_sense_p_ext_uq1 vss 0.58074f
C46 decision_n reset 0.31048f
C47 vss vdd_ext 0.19458f
C48 latch_sense_p_ext_uq1 reset 0.19529f
C49 vdd row_drive 0.1964f
C50 physical_preamp_n.sar_comparator_input latch_sense_p_ext_uq1 0.40781f
C51 reset vdd_ext 4.48789f
C52 physical_preamp_n.sar_comparator_input vdd_ext 0.01545f
C53 physical_preamp_n.sar_comparator_input m4_51060_36440# 0.12909f
C54 decision_n decision_p 2.54301f
C55 eval latch_sense_p_ext_uq1 0.19752f
C56 iso_tail_ext row_drive 2.39704f
C57 latch_sense_p_ext_uq1 decision_p 0.37635f
C58 sar_comparator_input row_drive 5.22878f
C59 eval vdd_ext 0
C60 sar_readout_12b_0.vss row_drive 0.29433f
C61 m4_45060_36440# row_drive 0.12597f
C62 decision_p vdd_ext 3.8282f
C63 row_drive sar_readout_12b_0.vdd 0.58157f
C64 m1_68300_3080# vdd_ext 0.24419f
C65 vss vss_escape 36.2394f
C66 vdd vss_escape 36.7f
C67 iso_tail_ext vss_escape 77.06784f
C68 decision_p vss_escape 16.30635f
C69 tail_ext vss_escape 0.14131p
C70 latch_sense_p_ext_uq1 vss_escape 56.09965f
C71 vdd_ext vss_escape 0.25166p
C72 m4_51060_36440# vss_escape 0.11856f ; **FLOATING
C73 m4_45060_36440# vss_escape 0.09675f ; **FLOATING
C74 sar_readout_12b_0.vss vss_escape 1.33686f ; **FLOATING
C75 row_dac_10b_0.vss vss_escape 1.40333f ; **FLOATING
C76 row_dac_10b_0.vdd vss_escape 1.33457f ; **FLOATING
C77 sar_readout_12b_0.vdd vss_escape 1.77614f ; **FLOATING
C78 m1_68300_3080# vss_escape 7.89552f ; **FLOATING
C79 shared_converter_mux_0.vss vss_escape 1.39454f ; **FLOATING
C80 shared_converter_mux_0.mux_bus vss_escape 2.86922f ; **FLOATING
C81 shared_converter_mux_0.vdd vss_escape 0.95985f ; **FLOATING
C82 physical_preamp_n.latch_sense_n_ext vss_escape 4.69839f
.ends
