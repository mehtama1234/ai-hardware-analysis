* NGSPICE file created from aimc_converter_macro_active_candidate.ext - technology: sky130A

.subckt sky130_transistor_active_isolation_pair iso_tail iso_p iso_n sense_p sense_n
+ m1_3440_500# m1_1000_500# m2_900_1400# VSUBS
X0 iso_tail sense_n iso_n VSUBS sky130_fd_pr__nfet_01v8 ad=3.12 pd=7.6 as=3.36 ps=8 w=1.2 l=0.6
X1 iso_p sense_p iso_tail VSUBS sky130_fd_pr__nfet_01v8 ad=3.36 pd=8 as=3.12 ps=7.6 w=1.2 l=0.6
C0 iso_n iso_p 0.00782f
C1 iso_tail sense_p 0.12292f
C2 m1_3440_500# sense_n 0.04555f
C3 sense_n iso_n 0.02157f
C4 iso_tail m1_1000_500# 0.0015f
C5 iso_tail m2_900_1400# 0.34398f
C6 m1_1000_500# sense_p 0.04555f
C7 m2_900_1400# sense_p 0.04273f
C8 m2_900_1400# m1_1000_500# 0.01113f
C9 m1_3440_500# iso_n 0.0015f
C10 iso_tail iso_p 0.05749f
C11 sense_n iso_tail 0.11179f
C12 sense_p iso_p 0.02157f
C13 m1_1000_500# iso_p 0.0015f
C14 m2_900_1400# iso_p 0.41846f
C15 sense_n m2_900_1400# 0.04273f
C16 m1_3440_500# iso_tail 0.0015f
C17 iso_tail iso_n 0.05717f
C18 m1_3440_500# m2_900_1400# 0.01113f
C19 m2_900_1400# iso_n 0.41846f
C20 iso_n VSUBS 1.04634f
C21 iso_p VSUBS 1.04634f
C22 iso_tail VSUBS 4.24257f
C23 m2_900_1400# VSUBS 1.01648f
C24 m1_3440_500# VSUBS 0.31893f
C25 m1_1000_500# VSUBS 0.31893f
.ends

.subckt escaped_input_latch out_p out_n latch_sense_p latch_sense_n tail reset vdd
+ vss eval sense_p sense_n iso_tail vdd_active
X0 out_p out_n vdd_active vdd_active sky130_fd_pr__pfet_01v8 ad=3.36 pd=8 as=3.12 ps=7.6 w=1.2 l=0.6
X1 vdd reset out_n vdd sky130_fd_pr__pfet_01v8 ad=3.12 pd=7.6 as=3.36 ps=8 w=1.2 l=0.6
X2 tail out_p out_n vss sky130_fd_pr__nfet_01v8 ad=3.12 pd=7.6 as=3.36 ps=8 w=1.2 l=0.6
X3 out_p reset vdd vdd sky130_fd_pr__pfet_01v8 ad=3.36 pd=8 as=3.12 ps=7.6 w=1.2 l=0.6
X4 out_p out_n tail vss sky130_fd_pr__nfet_01v8 ad=3.36 pd=8 as=3.12 ps=7.6 w=1.2 l=0.6
X5 tail latch_sense_n out_n vss sky130_fd_pr__nfet_01v8 ad=3.12 pd=7.6 as=3.36 ps=8 w=1.2 l=0.6
X6 tail eval vss vss sky130_fd_pr__nfet_01v8 ad=16.2 pd=17.4 as=16.2 ps=17.4 w=6 l=0.6
X7 out_p latch_sense_p tail vss sky130_fd_pr__nfet_01v8 ad=3.36 pd=8 as=3.12 ps=7.6 w=1.2 l=0.6
X8 iso_tail sense_n latch_sense_n vss sky130_fd_pr__nfet_01v8 ad=3.12 pd=7.6 as=3.36 ps=8 w=1.2 l=0.6
X9 vdd_active out_p out_n vdd_active sky130_fd_pr__pfet_01v8 ad=3.12 pd=7.6 as=3.36 ps=8 w=1.2 l=0.6
X10 latch_sense_p sense_p iso_tail vss sky130_fd_pr__nfet_01v8 ad=3.36 pd=8 as=3.12 ps=7.6 w=1.2 l=0.6
C0 latch_sense_p sense_p 0.22977f
C1 out_p reset 0.376f
C2 tail vdd_active 0.9938f
C3 latch_sense_p out_p 0.18428f
C4 sense_n latch_sense_n 0.22977f
C5 tail out_n 0.46979f
C6 tail vdd 0.9918f
C7 out_n vdd_active 3.16716f
C8 latch_sense_p iso_tail 0.20888f
C9 vdd out_n 0.77104f
C10 sense_n iso_tail 0.10725f
C11 tail reset 0.16491f
C12 latch_sense_p tail 0.0334f
C13 eval tail 0.35666f
C14 out_n reset 0.31048f
C15 iso_tail sense_p 0.26105f
C16 vdd reset 4.47121f
C17 iso_tail latch_sense_n 0.20888f
C18 tail latch_sense_n 0.0334f
C19 tail out_p 0.46979f
C20 out_p vdd_active 3.06556f
C21 out_n latch_sense_n 0.18428f
C22 out_n out_p 2.54301f
C23 vdd out_p 0.76206f
C24 iso_tail vss 29.23796f
C25 latch_sense_n vss 1.7693f
C26 latch_sense_p vss 1.56796f
C27 out_n vss 13.58747f
C28 tail vss 89.03816f
C29 vdd_active vss 90.11912f
C30 vdd vss 78.65506f
.ends

.subckt aimc_converter_macro_active_candidate vss vdd row_drive sar_comparator_input
+ decision_p decision_n reset eval vss_escape latch_sense_p_ext latch_sense_n_ext
+ iso_tail_ext tail_ext vdd_ext preamp_iso_tail_ext
Xphysical_preamp_0 physical_preamp_0/iso_tail physical_preamp_0/iso_p physical_preamp_0/iso_n
+ physical_preamp_0/sense_p physical_preamp_0/sense_n sar_comparator_input row_drive
+ physical_preamp_0/m2_900_1400# vss_escape sky130_transistor_active_isolation_pair
Xconverter_latch_0 decision_p decision_n latch_sense_p_ext latch_sense_n_ext tail_ext
+ reset vdd_ext vss_escape eval row_drive sar_comparator_input iso_tail_ext vdd_ext
+ escaped_input_latch
C0 physical_preamp_0/iso_p physical_preamp_0/m2_900_1400# 0
C1 row_drive iso_tail_ext 1.71857f
C2 row_drive sar_readout_12b_0/vss 0.29422f
C3 shared_converter_mux_0/mux_bus row_drive 0.06281f
C4 physical_preamp_0/sense_p physical_preamp_0/m2_900_1400# -0.00637f
C5 row_drive row_dac_10b_0/vdd 1.11462f
C6 vdd_ext sar_comparator_input 1.05718f
C7 vdd_ext latch_sense_p_ext 3.43095f
C8 vss latch_sense_p_ext 0.23329f
C9 physical_preamp_0/sense_n sar_comparator_input 0.02993f
C10 vdd_ext shared_converter_mux_0/vdd 0
C11 shared_converter_mux_0/vdd vss 0.2816f
C12 row_drive sar_readout_12b_0/vdd 0.57218f
C13 shared_converter_mux_0/mux_bus shared_converter_mux_0/vss 1.56188f
C14 latch_sense_n_ext sar_comparator_input -0.18697f
C15 row_drive physical_preamp_0/m2_900_1400# -0.00731f
C16 row_drive physical_preamp_0/iso_p -0
C17 reset tail_ext 0.01085f
C18 row_drive vdd 0.1964f
C19 physical_preamp_0/sense_p row_drive 0.03601f
C20 physical_preamp_0/iso_n physical_preamp_0/m2_900_1400# -0
C21 decision_p tail_ext 0.01085f
C22 iso_tail_ext vdd_ext 0.86179f
C23 row_drive shared_converter_mux_0/vss 0.00246f
C24 vdd_ext sar_readout_12b_0/vss 0.93663f
C25 shared_converter_mux_0/mux_bus vdd_ext 0.00217f
C26 row_dac_10b_0/vdd row_dac_10b_0/vss 0.78467f
C27 shared_converter_mux_0/mux_bus vss 0.03132f
C28 iso_tail_ext latch_sense_n_ext -0.08311f
C29 sar_readout_12b_0/vdd vdd_ext 1.39936f
C30 row_drive physical_preamp_0/iso_tail 0.02322f
C31 eval tail_ext 0.01085f
C32 vdd_ext physical_preamp_0/m2_900_1400# 0.07266f
C33 reset vdd_ext 0.01669f
C34 physical_preamp_0/sense_n physical_preamp_0/m2_900_1400# -0.00318f
C35 physical_preamp_0/iso_p vdd_ext 0.02484f
C36 physical_preamp_0/sense_p vdd_ext 0.03284f
C37 iso_tail_ext sar_comparator_input 0.05996f
C38 iso_tail_ext latch_sense_p_ext -0.08311f
C39 row_drive row_dac_10b_0/vss 1.08123f
C40 row_drive vdd_ext 2.61675f
C41 row_drive vss 0.22445f
C42 decision_p vdd_ext 0
C43 shared_converter_mux_0/mux_bus shared_converter_mux_0/vdd 1.55306f
C44 row_drive latch_sense_n_ext 0.20099f
C45 vdd_ext physical_preamp_0/iso_n 0.0106f
C46 vdd_ext shared_converter_mux_0/vss 0
C47 m1_69940_2940# preamp_iso_tail_ext 0.03103f
C48 physical_preamp_0/m2_900_1400# sar_comparator_input 0.16477f
C49 physical_preamp_0/iso_p sar_comparator_input 0.02717f
C50 vdd_ext eval 0
C51 physical_preamp_0/sense_p sar_comparator_input 0.04049f
C52 physical_preamp_0/iso_tail vdd_ext 0.30577f
C53 row_drive sar_comparator_input 5.23145f
C54 row_drive latch_sense_p_ext 0.01436f
C55 row_drive shared_converter_mux_0/vdd 0.00246f
C56 iso_tail_ext sar_readout_12b_0/vss 0.60045f
C57 physical_preamp_0/iso_n sar_comparator_input 0.027f
C58 iso_tail_ext sar_readout_12b_0/vdd 0.27521f
C59 sar_readout_12b_0/vdd sar_readout_12b_0/vss 0.49712f
C60 vdd_ext vss 0.20794f
C61 physical_preamp_0/sense_n vdd_ext 0.0039f
C62 decision_n tail_ext 0.01085f
C63 latch_sense_n_ext vdd_ext 3.48444f
C64 latch_sense_n_ext vss 0.23329f
C65 physical_preamp_0/iso_tail sar_comparator_input 0.0361f
C66 preamp_iso_tail_ext vss_escape 0.18641f
C67 vss vss_escape 36.6898f
C68 vdd vss_escape 36.7f
C69 m1_69940_2940# vss_escape 0.19727f ; **FLOATING
C70 iso_tail_ext vss_escape -1.05232f
C71 sar_comparator_input vss_escape 10.26652f
C72 latch_sense_n_ext vss_escape -0.64712f
C73 latch_sense_p_ext vss_escape -0.87822f
C74 decision_n vss_escape 3.8093f
C75 eval vss_escape 0.78348f
C76 row_drive vss_escape 19.0962f
C77 vdd_ext vss_escape 47.37503f
.ends
