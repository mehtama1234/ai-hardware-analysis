* NGSPICE file created from aimc_converter_macro_active_candidate.ext - technology: sky130A

.subckt escaped_input_latch out_p out_n latch_sense_p latch_sense_n tail reset vdd
+ vss eval sense_p sense_n iso_tail vdd_active
X0 out_p out_n vdd_active vdd_active sky130_fd_pr__pfet_01v8 ad=6.72 pd=10.4 as=6.24 ps=10 w=2.4 l=0.6
X1 vdd reset out_n vdd sky130_fd_pr__pfet_01v8 ad=3.12 pd=7.6 as=3.36 ps=8 w=1.2 l=0.6
X2 tail out_p out_n vss sky130_fd_pr__nfet_01v8 ad=12.48 pd=14.8 as=13.44 ps=15.2 w=4.8 l=0.6
X3 out_p reset vdd vdd sky130_fd_pr__pfet_01v8 ad=3.36 pd=8 as=3.12 ps=7.6 w=1.2 l=0.6
X4 out_p out_n tail vss sky130_fd_pr__nfet_01v8 ad=13.44 pd=15.2 as=12.48 ps=14.8 w=4.8 l=0.6
X5 tail latch_sense_n out_n vss sky130_fd_pr__nfet_01v8 ad=12.48 pd=14.8 as=13.44 ps=15.2 w=4.8 l=0.6
X6 tail eval vss vss sky130_fd_pr__nfet_01v8 ad=16.2 pd=17.4 as=16.2 ps=17.4 w=6 l=0.6
X7 out_p latch_sense_p tail vss sky130_fd_pr__nfet_01v8 ad=13.44 pd=15.2 as=12.48 ps=14.8 w=4.8 l=0.6
X8 iso_tail sense_n latch_sense_n vss sky130_fd_pr__nfet_01v8 ad=3.12 pd=7.6 as=3.36 ps=8 w=1.2 l=0.6
X9 vdd_active out_p out_n vdd_active sky130_fd_pr__pfet_01v8 ad=6.24 pd=10 as=6.72 ps=10.4 w=2.4 l=0.6
X10 latch_sense_p sense_p iso_tail vss sky130_fd_pr__nfet_01v8 ad=3.36 pd=8 as=3.12 ps=7.6 w=1.2 l=0.6
C0 eval tail 0.35666f
C1 latch_sense_n out_n 0.1874f
C2 out_n reset 0.31048f
C3 reset vdd 4.47121f
C4 out_p latch_sense_p 0.1874f
C5 out_p reset 0.376f
C6 out_n tail 0.51868f
C7 vdd tail 0.9918f
C8 out_p tail 0.51868f
C9 sense_p latch_sense_p 0.22977f
C10 latch_sense_n sense_n 0.22977f
C11 out_n vdd 0.77104f
C12 vdd_active tail 0.9938f
C13 out_p out_n 2.60132f
C14 out_p vdd 0.76206f
C15 iso_tail sense_p 0.26105f
C16 iso_tail sense_n 0.10725f
C17 out_n vdd_active 2.93626f
C18 latch_sense_p tail 0.0334f
C19 latch_sense_n tail 0.0334f
C20 reset tail 0.16491f
C21 out_p vdd_active 2.83065f
C22 iso_tail latch_sense_p 0.20888f
C23 latch_sense_n iso_tail 0.20888f
C24 iso_tail vss 29.23796f
C25 latch_sense_n vss 1.7693f
C26 latch_sense_p vss 1.56796f
C27 out_n vss 12.9274f
C28 tail vss 86.83939f
C29 vdd_active vss 89.13274f
C30 vdd vss 78.65506f
.ends

.subckt aimc_converter_macro_active_candidate vss vdd row_drive sar_comparator_input
+ decision_p decision_n reset eval vss_escape latch_sense_p_ext latch_sense_n_ext
+ iso_tail_ext tail_ext vdd_ext
Xconverter_latch_0 decision_p decision_n latch_sense_p_ext latch_sense_n_ext tail_ext
+ reset vdd_ext vss_escape eval row_drive sar_comparator_input iso_tail_ext vdd_ext
+ escaped_input_latch
C0 sar_comparator_input iso_tail_ext 0.08712f
C1 decision_n tail_ext 0.01085f
C2 shared_converter_mux_0/vdd shared_converter_mux_0/mux_bus 1.55306f
C3 row_dac_10b_0/vss row_drive 1.08123f
C4 row_dac_10b_0/vdd row_drive 1.11409f
C5 vdd_ext row_drive 1.55835f
C6 vdd_ext reset 0.01669f
C7 row_dac_10b_0/vss row_dac_10b_0/vdd 0.78467f
C8 vss shared_converter_mux_0/mux_bus 0.03132f
C9 reset tail_ext 0.01085f
C10 shared_converter_mux_0/vdd row_drive 0.00246f
C11 iso_tail_ext sar_readout_12b_0/vdd 0.27625f
C12 vdd_ext shared_converter_mux_0/vdd 0
C13 vdd_ext eval 0
C14 vss row_drive 0.22445f
C15 latch_sense_p_ext row_drive 0
C16 vdd_ext vss 0.19458f
C17 sar_readout_12b_0/vss sar_readout_12b_0/vdd 0.49712f
C18 vdd_ext decision_p 0
C19 eval tail_ext 0.01085f
C20 sar_readout_12b_0/vss iso_tail_ext 0.60149f
C21 decision_p tail_ext 0.01085f
C22 shared_converter_mux_0/vdd vss 0.2816f
C23 shared_converter_mux_0/vss shared_converter_mux_0/mux_bus 1.56188f
C24 sar_readout_12b_0/vdd row_drive 0.33461f
C25 iso_tail_ext row_drive 0.26323f
C26 vdd_ext sar_readout_12b_0/vdd 1.39936f
C27 latch_sense_p_ext vss 0.23329f
C28 vdd_ext iso_tail_ext 0.31557f
C29 shared_converter_mux_0/mux_bus row_drive 0.06281f
C30 shared_converter_mux_0/vss row_drive 0.00246f
C31 sar_readout_12b_0/vss row_drive 0.21493f
C32 vdd_ext shared_converter_mux_0/mux_bus 0.00217f
C33 shared_converter_mux_0/vss vdd_ext 0
C34 vdd_ext sar_readout_12b_0/vss 0.93663f
C35 vss latch_sense_n_ext 0.23329f
C36 vdd row_drive 0.1964f
C37 vss vss_escape 30.5941f
C38 vdd vss_escape 30.5941f
C39 iso_tail_ext vss_escape -0.88568f
C40 sar_comparator_input vss_escape 1.15812f
C41 decision_n vss_escape 3.8093f
C42 eval vss_escape 0.78348f
C43 row_drive vss_escape 7.1806f
C44 vdd_ext vss_escape 34.16415f
.ends
