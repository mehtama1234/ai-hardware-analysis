* NGSPICE file created from aimc_converter_macro_active_candidate.ext - technology: sky130A

.subckt sky130_transistor_active_isolation_pair iso_tail iso_p iso_n sense_p sense_n
+ VSUBS
X0 iso_tail sense_n iso_n VSUBS sky130_fd_pr__nfet_01v8 ad=3.12 pd=7.6 as=3.36 ps=8 w=1.2 l=0.6
X1 iso_p sense_p iso_tail VSUBS sky130_fd_pr__nfet_01v8 ad=3.36 pd=8 as=3.12 ps=7.6 w=1.2 l=0.6
C0 iso_p m1_1000_500# 0.0015f
C1 sense_n iso_n 0.02157f
C2 iso_p iso_n 0.00782f
C3 iso_tail m2_900_1400# 0.34398f
C4 iso_tail m1_3440_500# 0.0015f
C5 sense_n iso_tail 0.11179f
C6 iso_p iso_tail 0.05749f
C7 sense_p m2_900_1400# 0.04273f
C8 m1_1000_500# iso_tail 0.0015f
C9 iso_p sense_p 0.02157f
C10 iso_n iso_tail 0.05717f
C11 m1_3440_500# m2_900_1400# 0.01113f
C12 sense_n m2_900_1400# 0.04273f
C13 iso_p m2_900_1400# 0.41846f
C14 sense_p m1_1000_500# 0.04555f
C15 sense_n m1_3440_500# 0.04555f
C16 m1_1000_500# m2_900_1400# 0.01113f
C17 iso_n m2_900_1400# 0.41846f
C18 sense_p iso_tail 0.12292f
C19 iso_n m1_3440_500# 0.0015f
C20 iso_n VSUBS 1.04634f
C21 iso_p VSUBS 1.04634f
C22 iso_tail VSUBS 4.24257f
C23 m2_900_1400# VSUBS 1.01648f ; **FLOATING
C24 m1_3440_500# VSUBS 0.31893f ; **FLOATING
C25 m1_1000_500# VSUBS 0.31893f ; **FLOATING
.ends

.subckt escaped_input_latch out_p out_n latch_sense_p latch_sense_n tail reset vdd
+ vss eval sense_p sense_n iso_tail vdd_active
X0 out_p out_n vdd_active vdd_active sky130_fd_pr__pfet_01v8 ad=3.36 pd=8 as=3.12 ps=7.6 w=1.2 l=0.6
X1 vdd reset out_n vdd sky130_fd_pr__pfet_01v8 ad=3.12 pd=7.6 as=3.36 ps=8 w=1.2 l=0.6
X2 tail out_p out_n vss sky130_fd_pr__nfet_01v8 ad=3.12 pd=7.6 as=3.36 ps=8 w=1.2 l=0.6
X3 out_p reset vdd vdd sky130_fd_pr__pfet_01v8 ad=3.36 pd=8 as=3.12 ps=7.6 w=1.2 l=0.6
X4 out_p out_n tail vss sky130_fd_pr__nfet_01v8 ad=3.36 pd=8 as=3.12 ps=7.6 w=1.2 l=0.6
X5 tail latch_sense_n out_n vss sky130_fd_pr__nfet_01v8 ad=3.12 pd=7.6 as=3.36 ps=8 w=1.2 l=0.6
X6 tail eval vss vss sky130_fd_pr__nfet_01v8 ad=16.2 pd=17.4 as=16.2 ps=17.4 w=6 l=0.6
X7 out_p latch_sense_p tail vss sky130_fd_pr__nfet_01v8 ad=3.36 pd=8 as=3.12 ps=7.6 w=1.2 l=0.6
X8 iso_tail sense_n latch_sense_n vss sky130_fd_pr__nfet_01v8 ad=3.12 pd=7.6 as=3.36 ps=8 w=1.2 l=0.6
X9 vdd_active out_p out_n vdd_active sky130_fd_pr__pfet_01v8 ad=3.12 pd=7.6 as=3.36 ps=8 w=1.2 l=0.6
X10 latch_sense_p sense_p iso_tail vss sky130_fd_pr__nfet_01v8 ad=3.36 pd=8 as=3.12 ps=7.6 w=1.2 l=0.6
C0 reset out_n 0.31048f
C1 reset out_p 0.376f
C2 latch_sense_n iso_tail 0.20888f
C3 tail vdd 0.9918f
C4 sense_p latch_sense_p 0.22977f
C5 sense_n iso_tail 0.10725f
C6 iso_tail latch_sense_p 0.20888f
C7 out_p out_n 2.54301f
C8 latch_sense_n out_n 0.18428f
C9 eval tail 0.35666f
C10 reset tail 0.16491f
C11 latch_sense_n sense_n 0.22977f
C12 out_p latch_sense_p 0.18428f
C13 out_n tail 0.46979f
C14 out_p tail 0.46979f
C15 latch_sense_n tail 0.0334f
C16 tail latch_sense_p 0.0334f
C17 reset vdd 4.47121f
C18 vdd_active out_n 3.16716f
C19 out_p vdd_active 3.06556f
C20 sense_p iso_tail 0.26105f
C21 out_n vdd 0.77104f
C22 out_p vdd 0.76206f
C23 vdd_active tail 0.9938f
C24 iso_tail vss 29.23796f
C25 latch_sense_n vss 1.7693f
C26 latch_sense_p vss 1.56796f
C27 out_n vss 13.58747f
C28 tail vss 89.03816f
C29 vdd_active vss 90.11912f
C30 vdd vss 78.65506f
.ends

.subckt aimc_converter_macro_active_candidate vss vdd row_drive sar_comparator_input
+ decision_p decision_n reset eval vss_escape latch_sense_p_ext latch_sense_n_ext
+ iso_tail_ext tail_ext vdd_ext
Xphysical_preamp_0 physical_preamp_0/iso_tail physical_preamp_0/iso_p physical_preamp_0/iso_n
+ physical_preamp_0/sense_p physical_preamp_0/sense_n vss_escape sky130_transistor_active_isolation_pair
Xconverter_latch_0 decision_p decision_n latch_sense_p_ext latch_sense_n_ext tail_ext
+ reset vdd_ext vss_escape eval row_drive sar_comparator_input iso_tail_ext vdd_ext
+ escaped_input_latch
C0 shared_converter_mux_0/vdd vdd_ext 0
C1 row_drive shared_converter_mux_0/vdd 0.00246f
C2 row_drive latch_sense_p_ext 0
C3 shared_converter_mux_0/vss vdd_ext 0
C4 eval tail_ext 0.01085f
C5 shared_converter_mux_0/vss row_drive 0.00246f
C6 decision_p vdd_ext 0
C7 iso_tail_ext vdd_ext 0.31557f
C8 iso_tail_ext row_drive 0.26323f
C9 vss vdd_ext 0.19458f
C10 sar_readout_12b_0/vdd vdd_ext 1.39936f
C11 row_drive vss 0.22445f
C12 row_drive sar_readout_12b_0/vdd 0.33461f
C13 vdd_ext shared_converter_mux_0/mux_bus 0.00217f
C14 row_drive shared_converter_mux_0/mux_bus 0.06281f
C15 sar_readout_12b_0/vss vdd_ext 0.93663f
C16 row_drive sar_readout_12b_0/vss 0.21493f
C17 vss shared_converter_mux_0/vdd 0.2816f
C18 shared_converter_mux_0/vdd shared_converter_mux_0/mux_bus 1.55306f
C19 reset vdd_ext 0.01669f
C20 vss latch_sense_p_ext 0.23329f
C21 shared_converter_mux_0/vss shared_converter_mux_0/mux_bus 1.56188f
C22 iso_tail_ext sar_readout_12b_0/vdd 0.27625f
C23 row_drive row_dac_10b_0/vdd 1.11409f
C24 vss shared_converter_mux_0/mux_bus 0.03132f
C25 eval vdd_ext 0
C26 iso_tail_ext sar_readout_12b_0/vss 0.60149f
C27 row_dac_10b_0/vss row_dac_10b_0/vdd 0.78467f
C28 decision_p tail_ext 0.01085f
C29 sar_readout_12b_0/vdd sar_readout_12b_0/vss 0.49712f
C30 iso_tail_ext sar_comparator_input 0.08712f
C31 row_drive vdd_ext 1.55835f
C32 reset tail_ext 0.01085f
C33 decision_n tail_ext 0.01085f
C34 row_dac_10b_0/vss row_drive 1.08123f
C35 vdd row_drive 0.1964f
C36 vss latch_sense_n_ext 0.23329f
C37 vss vss_escape 36.7f
C38 vdd vss_escape 36.7f
C39 iso_tail_ext vss_escape -0.88568f
C40 sar_comparator_input vss_escape 1.15812f
C41 decision_n vss_escape 3.8093f
C42 eval vss_escape 0.78348f
C43 row_drive vss_escape 7.1806f
C44 vdd_ext vss_escape 34.16415f
.ends
