* NGSPICE file created from aimc_converter_macro_active_candidate_flat.ext - technology: sky130A

.subckt aimc_converter_macro_active_candidate_flat vss vdd row_drive sar_comparator_input
+ decision_p decision_n reset eval vss_escape latch_sense_p_ext latch_sense_n_ext
+ iso_tail_ext tail_ext vdd_ext
X0 latch_sense_n_ext physical_preamp_n.sar_comparator_input latch_sense_n_ext vss_escape sky130_fd_pr__nfet_01v8 ad=3.12 pd=7.6 as=12.96 ps=31.2 w=1.2 l=0.6
X1 vdd_ext decision_p decision_n vdd_ext sky130_fd_pr__pfet_01v8 ad=3.12 pd=7.6 as=3.36 ps=8 w=1.2 l=0.6
X2 tail_ext eval vss_escape vss_escape sky130_fd_pr__nfet_01v8 ad=16.2 pd=17.4 as=16.2 ps=17.4 w=6 l=0.6
X3 decision_p latch_sense_p_ext tail_ext vss_escape sky130_fd_pr__nfet_01v8 ad=3.36 pd=8 as=3.12 ps=7.6 w=1.2 l=0.6
X4 vdd_ext reset decision_n vdd_ext sky130_fd_pr__pfet_01v8 ad=3.12 pd=7.6 as=3.36 ps=8 w=1.2 l=0.6
X5 tail_ext latch_sense_n_ext decision_n vss_escape sky130_fd_pr__nfet_01v8 ad=3.12 pd=7.6 as=3.36 ps=8 w=1.2 l=0.6
X6 decision_p decision_n vdd_ext vdd_ext sky130_fd_pr__pfet_01v8 ad=3.36 pd=8 as=3.12 ps=7.6 w=1.2 l=0.6
X7 tail_ext decision_p decision_n vss_escape sky130_fd_pr__nfet_01v8 ad=3.12 pd=7.6 as=3.36 ps=8 w=1.2 l=0.6
X8 latch_sense_p_ext row_drive iso_tail_ext vss_escape sky130_fd_pr__nfet_01v8 ad=3.36 pd=8 as=3.12 ps=7.6 w=1.2 l=0.6
X9 iso_tail_ext sar_comparator_input latch_sense_n_ext vss_escape sky130_fd_pr__nfet_01v8 ad=3.12 pd=7.6 as=3.36 ps=8 w=1.2 l=0.6
X10 physical_preamp_p.latch_sense_p_ext row_drive latch_sense_n_ext vss_escape sky130_fd_pr__nfet_01v8 ad=3.36 pd=8 as=3.12 ps=7.6 w=1.2 l=0.6
X11 decision_p reset vdd_ext vdd_ext sky130_fd_pr__pfet_01v8 ad=3.36 pd=8 as=3.12 ps=7.6 w=1.2 l=0.6
X12 decision_p decision_n tail_ext vss_escape sky130_fd_pr__nfet_01v8 ad=3.36 pd=8 as=3.12 ps=7.6 w=1.2 l=0.6
C0 physical_preamp_n.sar_comparator_input vdd_ext 0.01545f
C1 iso_tail_ext latch_sense_p_ext 0.1295f
C2 m4_45060_36440# latch_sense_n_ext 0.04583f
C3 sar_readout_12b_0.vdd row_drive 0.58157f
C4 row_dac_10b_0.vdd row_drive 1.11462f
C5 physical_preamp_n.sar_comparator_input row_drive 0.12269f
C6 m1_68300_3080# vdd_ext 0.24419f
C7 vdd_ext eval 0
C8 tail_ext eval 0.36751f
C9 reset decision_p 0.376f
C10 vdd_ext m4_45060_36440# 0.01404f
C11 vdd_ext latch_sense_p_ext 4.11646f
C12 latch_sense_p_ext tail_ext 0.99589f
C13 vdd_ext shared_converter_mux_0.vdd 0
C14 vdd_ext shared_converter_mux_0.mux_bus 0.00217f
C15 m1_68300_3080# row_drive 2.68328f
C16 vss latch_sense_n_ext 0.29037f
C17 vdd_ext shared_converter_mux_0.vss 0
C18 m4_45060_36440# row_drive 0.13059f
C19 latch_sense_p_ext row_drive 0.70701f
C20 shared_converter_mux_0.vdd row_drive 0.00246f
C21 iso_tail_ext sar_comparator_input 0.16721f
C22 shared_converter_mux_0.mux_bus row_drive 0.06281f
C23 vdd_ext vss 0.19458f
C24 sar_comparator_input latch_sense_n_ext 0.04367f
C25 shared_converter_mux_0.vss row_drive 0.00246f
C26 decision_n decision_p 2.54301f
C27 sar_readout_12b_0.vss iso_tail_ext 0.60045f
C28 decision_n reset 0.31048f
C29 latch_sense_p_ext eval 0.19752f
C30 vdd_ext sar_comparator_input 1.06679f
C31 vss row_drive 0.22445f
C32 physical_preamp_p.latch_sense_p_ext latch_sense_n_ext 0.09914f
C33 vdd_ext decision_p 3.8282f
C34 decision_p tail_ext 0.48065f
C35 vdd_ext reset 4.48789f
C36 reset tail_ext 0.17577f
C37 shared_converter_mux_0.vdd shared_converter_mux_0.mux_bus 1.55306f
C38 m4_51060_36440# latch_sense_n_ext 0.00179f
C39 vdd_ext physical_preamp_p.latch_sense_p_ext 0.01185f
C40 vdd_ext sar_readout_12b_0.vss 0.93663f
C41 sar_comparator_input row_drive 5.22878f
C42 shared_converter_mux_0.mux_bus shared_converter_mux_0.vss 1.56188f
C43 iso_tail_ext latch_sense_n_ext 0.12999f
C44 vdd_ext m4_51060_36440# 0.01404f
C45 vss latch_sense_p_ext 0.29037f
C46 shared_converter_mux_0.vdd vss 0.2816f
C47 physical_preamp_p.latch_sense_p_ext row_drive 0.08419f
C48 decision_n latch_sense_n_ext 0.37635f
C49 sar_readout_12b_0.vdd sar_readout_12b_0.vss 0.49712f
C50 shared_converter_mux_0.mux_bus vss 0.03132f
C51 sar_readout_12b_0.vss row_drive 0.29433f
C52 vdd_ext iso_tail_ext 0.86179f
C53 vdd_ext latch_sense_n_ext 4.72406f
C54 tail_ext latch_sense_n_ext 1.09601f
C55 vdd_ext decision_n 3.9382f
C56 physical_preamp_n.sar_comparator_input m4_51060_36440# 0.13059f
C57 decision_n tail_ext 0.48065f
C58 decision_p latch_sense_p_ext 0.37635f
C59 row_dac_10b_0.vss row_drive 1.08123f
C60 row_dac_10b_0.vdd row_dac_10b_0.vss 0.78467f
C61 sar_readout_12b_0.vdd iso_tail_ext 0.27521f
C62 iso_tail_ext row_drive 2.39704f
C63 reset latch_sense_p_ext 0.19529f
C64 vdd_ext tail_ext 1.9856f
C65 latch_sense_n_ext row_drive 1.18654f
C66 physical_preamp_n.sar_comparator_input latch_sense_n_ext 0.50162f
C67 vdd row_drive 0.1964f
C68 sar_readout_12b_0.vdd vdd_ext 1.39936f
C69 vdd_ext row_drive 3.84053f
C70 vss vss_escape 36.2394f
C71 vdd vss_escape 36.7f
C72 iso_tail_ext vss_escape 77.06784f
C73 latch_sense_p_ext vss_escape 47.08435f
C74 decision_p vss_escape 12.03439f
C75 tail_ext vss_escape 0.12518p
C76 latch_sense_n_ext vss_escape 9.0153f
C77 vdd_ext vss_escape 0.26867p
C78 m4_51060_36440# vss_escape 0.13014f ; **FLOATING
C79 m4_45060_36440# vss_escape 0.10814f ; **FLOATING
C80 sar_readout_12b_0.vss vss_escape 1.33686f ; **FLOATING
C81 row_dac_10b_0.vss vss_escape 1.40333f ; **FLOATING
C82 row_dac_10b_0.vdd vss_escape 1.33457f ; **FLOATING
C83 sar_readout_12b_0.vdd vss_escape 1.77614f ; **FLOATING
C84 m1_68300_3080# vss_escape 7.89552f ; **FLOATING
C85 shared_converter_mux_0.vss vss_escape 1.39454f ; **FLOATING
C86 shared_converter_mux_0.mux_bus vss_escape 2.86922f ; **FLOATING
C87 shared_converter_mux_0.vdd vss_escape 0.95985f ; **FLOATING
C88 physical_preamp_p.latch_sense_p_ext vss_escape 0.53398f
.ends
