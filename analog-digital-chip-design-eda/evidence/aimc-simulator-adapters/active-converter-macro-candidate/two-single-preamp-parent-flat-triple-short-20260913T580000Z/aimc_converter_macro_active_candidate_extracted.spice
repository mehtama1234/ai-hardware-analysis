* NGSPICE file created from aimc_converter_macro_active_candidate_flat_parallel.ext - technology: sky130A

.subckt aimc_converter_macro_active_candidate_flat_parallel vss vdd row_drive sar_comparator_input
+ decision_p decision_n reset eval vss_escape latch_sense_p_ext latch_sense_n_ext
+ iso_tail_ext tail_ext vdd_ext preamp_iso_tail_ext
X0 latch_sense_p_ext row_drive preamp_iso_tail_ext vss_escape sky130_fd_pr__nfet_01v8 ad=3.54 pd=8.3 as=3.3 ps=7.9 w=1.2 l=0.3
X1 vdd_ext decision_p decision_n vdd_ext sky130_fd_pr__pfet_01v8 ad=3.12 pd=7.6 as=3.36 ps=8 w=1.2 l=0.6
X2 tail_ext eval vss_escape vss_escape sky130_fd_pr__nfet_01v8 ad=16.2 pd=17.4 as=16.2 ps=17.4 w=6 l=0.6
X3 latch_sense_n_ext sar_comparator_input preamp_iso_tail_ext vss_escape sky130_fd_pr__nfet_01v8 ad=3.54 pd=8.3 as=3.3 ps=7.9 w=1.2 l=0.3
X4 latch_sense_p_ext row_drive preamp_iso_tail_ext vss_escape sky130_fd_pr__nfet_01v8 ad=3.54 pd=8.3 as=3.3 ps=7.9 w=1.2 l=0.3
X5 decision_p latch_sense_p_ext tail_ext vss_escape sky130_fd_pr__nfet_01v8 ad=3.36 pd=8 as=3.12 ps=7.6 w=1.2 l=0.6
X6 latch_sense_p_ext row_drive preamp_iso_tail_ext vss_escape sky130_fd_pr__nfet_01v8 ad=3.54 pd=8.3 as=3.12 ps=7.6 w=1.2 l=0.45
X7 vdd_ext reset decision_n vdd_ext sky130_fd_pr__pfet_01v8 ad=3.12 pd=7.6 as=3.36 ps=8 w=1.2 l=0.6
X8 tail_ext latch_sense_n_ext decision_n vss_escape sky130_fd_pr__nfet_01v8 ad=3.12 pd=7.6 as=3.36 ps=8 w=1.2 l=0.6
X9 decision_p decision_n vdd_ext vdd_ext sky130_fd_pr__pfet_01v8 ad=3.36 pd=8 as=3.12 ps=7.6 w=1.2 l=0.6
X10 tail_ext decision_p decision_n vss_escape sky130_fd_pr__nfet_01v8 ad=3.12 pd=7.6 as=3.36 ps=8 w=1.2 l=0.6
X11 latch_sense_p_ext row_drive iso_tail_ext vss_escape sky130_fd_pr__nfet_01v8 ad=3.36 pd=8 as=3.12 ps=7.6 w=1.2 l=0.6
X12 iso_tail_ext sar_comparator_input latch_sense_n_ext vss_escape sky130_fd_pr__nfet_01v8 ad=3.12 pd=7.6 as=3.36 ps=8 w=1.2 l=0.6
X13 latch_sense_n_ext sar_comparator_input preamp_iso_tail_ext vss_escape sky130_fd_pr__nfet_01v8 ad=3.54 pd=8.3 as=3.3 ps=7.9 w=1.2 l=0.3
X14 latch_sense_n_ext sar_comparator_input preamp_iso_tail_ext vss_escape sky130_fd_pr__nfet_01v8 ad=3.54 pd=8.3 as=3.12 ps=7.6 w=1.2 l=0.45
X15 decision_p reset vdd_ext vdd_ext sky130_fd_pr__pfet_01v8 ad=3.36 pd=8 as=3.12 ps=7.6 w=1.2 l=0.6
X16 decision_p decision_n tail_ext vss_escape sky130_fd_pr__nfet_01v8 ad=3.36 pd=8 as=3.12 ps=7.6 w=1.2 l=0.6
C0 vdd_ext m4_45060_36440# 0.01404f
C1 sar_readout_12b_0.vss sar_readout_12b_0.vdd 0.49712f
C2 vdd_ext decision_p 3.8282f
C3 vdd_ext shared_converter_mux_0.vss 0
C4 row_dac_10b_0.vss row_drive 1.08123f
C5 row_drive sar_comparator_input 5.59175f
C6 sar_readout_12b_0.vss row_drive 0.29433f
C7 iso_tail_ext latch_sense_p_ext 0.1295f
C8 latch_sense_n_ext sar_comparator_input 0.80688f
C9 latch_sense_p_ext preamp_iso_tail_ext 1.10215f
C10 shared_converter_mux_0.mux_bus vss 0.03132f
C11 reset latch_sense_p_ext 0.19529f
C12 m4_45060_36440# preamp_iso_tail_ext 0.00188f
C13 decision_n tail_ext 0.48065f
C14 reset decision_p 0.376f
C15 vdd_ext vss 0.19458f
C16 m1_68300_3080# row_drive 2.68328f
C17 row_dac_10b_0.vdd row_drive 1.11462f
C18 row_drive latch_sense_p_ext 1.41858f
C19 latch_sense_n_ext latch_sense_p_ext 0.77778f
C20 eval tail_ext 0.36751f
C21 row_drive m4_45060_36440# 0.10542f
C22 row_drive shared_converter_mux_0.vss 0.00246f
C23 shared_converter_mux_0.vdd vss 0.2816f
C24 vdd_ext decision_n 3.9382f
C25 m1_68300_3080# sar_comparator_input 0.05195f
C26 vdd_ext tail_ext 1.9856f
C27 row_dac_10b_0.vss row_dac_10b_0.vdd 0.78467f
C28 latch_sense_p_ext sar_comparator_input 0.12945f
C29 m4_45060_36440# sar_comparator_input 0.05954f
C30 vdd_ext eval 0
C31 vdd_ext shared_converter_mux_0.mux_bus 0.00217f
C32 row_drive vss 0.22445f
C33 vss latch_sense_n_ext 0.29037f
C34 reset decision_n 0.31048f
C35 reset tail_ext 0.17577f
C36 shared_converter_mux_0.vdd shared_converter_mux_0.mux_bus 1.55306f
C37 m4_45060_36440# latch_sense_p_ext 0.00631f
C38 decision_p latch_sense_p_ext 0.37635f
C39 vss sar_comparator_input 0.05708f
C40 decision_n latch_sense_n_ext 0.37635f
C41 vdd_ext shared_converter_mux_0.vdd 0
C42 vdd_ext iso_tail_ext 0.86179f
C43 tail_ext latch_sense_n_ext 1.09601f
C44 vdd_ext preamp_iso_tail_ext 0.14181f
C45 vdd_ext reset 4.48789f
C46 vdd_ext sar_readout_12b_0.vdd 1.39936f
C47 row_drive shared_converter_mux_0.mux_bus 0.06281f
C48 m4_32000_38940# latch_sense_n_ext 0.0096f
C49 decision_n sar_comparator_input 0.17131f
C50 vdd_ext row_drive 5.15257f
C51 vss latch_sense_p_ext 0.29037f
C52 vdd_ext latch_sense_n_ext 4.57292f
C53 sar_readout_12b_0.vdd iso_tail_ext 0.27521f
C54 row_drive m2_42000_41940# 0.12051f
C55 shared_converter_mux_0.vdd row_drive 0.00246f
C56 row_drive iso_tail_ext 2.39704f
C57 iso_tail_ext latch_sense_n_ext 0.12999f
C58 vdd_ext sar_comparator_input 1.83973f
C59 vdd_ext sar_readout_12b_0.vss 0.93663f
C60 tail_ext latch_sense_p_ext 0.99589f
C61 row_drive preamp_iso_tail_ext 0.38129f
C62 latch_sense_n_ext preamp_iso_tail_ext 0.99317f
C63 decision_n decision_p 2.54301f
C64 row_drive sar_readout_12b_0.vdd 0.58157f
C65 eval latch_sense_p_ext 0.19752f
C66 tail_ext decision_p 0.48065f
C67 iso_tail_ext sar_comparator_input 0.16721f
C68 sar_readout_12b_0.vss iso_tail_ext 0.60045f
C69 row_drive vdd 0.1964f
C70 m4_32000_38940# latch_sense_p_ext 0.00354f
C71 row_drive latch_sense_n_ext 0.84425f
C72 m1_68300_3080# vdd_ext 0.24419f
C73 preamp_iso_tail_ext sar_comparator_input 0.53166f
C74 vdd_ext latch_sense_p_ext 5.39974f
C75 shared_converter_mux_0.mux_bus shared_converter_mux_0.vss 1.56188f
C76 vss vss_escape 36.2394f
C77 vdd vss_escape 36.7f
C78 iso_tail_ext vss_escape 20.9682f
C79 decision_p vss_escape 21.0223f
C80 tail_ext vss_escape 0.18802p
C81 preamp_iso_tail_ext vss_escape 87.14401f
C82 vdd_ext vss_escape 0.2647p
C83 m4_45060_36440# vss_escape 0.07914f ; **FLOATING
C84 m4_32000_38940# vss_escape 0.1568f ; **FLOATING
C85 m2_42000_41940# vss_escape 3.91591f ; **FLOATING
C86 sar_readout_12b_0.vss vss_escape 1.33686f ; **FLOATING
C87 row_dac_10b_0.vss vss_escape 1.40333f ; **FLOATING
C88 row_dac_10b_0.vdd vss_escape 1.33457f ; **FLOATING
C89 sar_readout_12b_0.vdd vss_escape 1.77614f ; **FLOATING
C90 m1_68300_3080# vss_escape 7.89552f ; **FLOATING
C91 shared_converter_mux_0.vss vss_escape 1.39454f ; **FLOATING
C92 shared_converter_mux_0.mux_bus vss_escape 2.86922f ; **FLOATING
C93 shared_converter_mux_0.vdd vss_escape 0.95985f ; **FLOATING
.ends
