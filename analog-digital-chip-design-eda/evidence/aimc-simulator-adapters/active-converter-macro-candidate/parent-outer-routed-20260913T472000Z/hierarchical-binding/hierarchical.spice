* SPICE3 file created from aimc_converter_macro_active_candidate.ext - technology: sky130A

.subckt preamp_n_parent_bound preamp_iso_tail_ext latch_sense_n_ext sar_comparator_input
+ vss_escape
X0 latch_sense_n_ext sar_comparator_input preamp_iso_tail_ext vss_escape sky130_fd_pr__nfet_01v8 ad=3.36 pd=8 as=3.12 ps=7.6 w=1.2 l=0.6
C0 sar_comparator_input preamp_iso_tail_ext 0.02892f
C1 sar_comparator_input latch_sense_n_ext 0.02459f
C2 preamp_iso_tail_ext latch_sense_n_ext 0.03982f
C3 latch_sense_n_ext vss_escape 1.37396f
C4 preamp_iso_tail_ext vss_escape 1.3736f
.ends

.subckt preamp_p_parent_bound preamp_iso_tail_ext latch_sense_p_ext row_drive vss_escape
X0 latch_sense_p_ext row_drive preamp_iso_tail_ext vss_escape sky130_fd_pr__nfet_01v8 ad=3.36 pd=8 as=3.12 ps=7.6 w=1.2 l=0.6
C0 latch_sense_p_ext preamp_iso_tail_ext 0.03982f
C1 row_drive latch_sense_p_ext 0.02459f
C2 row_drive preamp_iso_tail_ext 0.02892f
C3 latch_sense_p_ext vss_escape 1.37396f
C4 preamp_iso_tail_ext vss_escape 1.3736f
.ends

.subckt escaped_input_latch out_p out_n latch_sense_p latch_sense_n tail reset vdd
+ vss eval sense_p sense_n iso_tail vdd_active
X0 out_p out_n vdd_active vdd_active sky130_fd_pr__pfet_01v8 ad=3.36 pd=8 as=3.12 ps=7.6 w=1.2 l=0.6
X1 vdd reset out_n vdd sky130_fd_pr__pfet_01v8 ad=3.12 pd=7.6 as=3.36 ps=8 w=1.2 l=0.6
X2 tail out_p out_n vss sky130_fd_pr__nfet_01v8 ad=3.12 pd=7.6 as=3.36 ps=8 w=1.2 l=0.6
X3 out_p reset vdd vdd sky130_fd_pr__pfet_01v8 ad=3.36 pd=8 as=3.12 ps=7.6 w=1.2 l=0.6
X4 out_p out_n tail vss sky130_fd_pr__nfet_01v8 ad=3.36 pd=8 as=3.12 ps=7.6 w=1.2 l=0.6
X5 tail latch_sense_n out_n vss sky130_fd_pr__nfet_01v8 ad=3.12 pd=7.6 as=3.36 ps=8 w=1.2 l=0.6
X6 tail eval vss vss sky130_fd_pr__nfet_01v8 ad=16.2 pd=17.4 as=16.2 ps=17.4 w=6 l=0.6
X7 out_p latch_sense_p tail vss sky130_fd_pr__nfet_01v8 ad=3.36 pd=8 as=3.12 ps=7.6 w=1.2 l=0.6
X8 iso_tail sense_n latch_sense_n vss sky130_fd_pr__nfet_01v8 ad=3.12 pd=7.6 as=3.36 ps=8 w=1.2 l=0.6
X9 vdd_active out_p out_n vdd_active sky130_fd_pr__pfet_01v8 ad=3.12 pd=7.6 as=3.36 ps=8 w=1.2 l=0.6
X10 latch_sense_p sense_p iso_tail vss sky130_fd_pr__nfet_01v8 ad=3.36 pd=8 as=3.12 ps=7.6 w=1.2 l=0.6
C0 out_n reset 0.31048f
C1 out_p out_n 2.54301f
C2 sense_n iso_tail 0.10725f
C3 iso_tail latch_sense_n 0.20888f
C4 iso_tail latch_sense_p 0.20888f
C5 out_n latch_sense_n 0.18428f
C6 out_n tail 0.46979f
C7 out_p reset 0.376f
C8 vdd_active out_n 3.16716f
C9 reset tail 0.16491f
C10 out_p tail 0.46979f
C11 eval tail 0.35666f
C12 vdd out_n 0.77104f
C13 out_p latch_sense_p 0.18428f
C14 sense_p latch_sense_p 0.22977f
C15 out_p vdd_active 3.06556f
C16 sense_n latch_sense_n 0.22977f
C17 tail latch_sense_n 0.0334f
C18 tail latch_sense_p 0.0334f
C19 vdd reset 4.47121f
C20 out_p vdd 0.76206f
C21 vdd_active tail 0.9938f
C22 vdd tail 0.9918f
C23 sense_p iso_tail 0.26105f
C24 iso_tail vss 29.23796f
C25 latch_sense_n vss 1.7693f
C26 latch_sense_p vss 1.56796f
C27 out_n vss 13.58747f
C28 tail vss 89.03816f
C29 vdd_active vss 90.11912f
C30 vdd vss 78.65506f
.ends

.subckt aimc_converter_macro_active_candidate vss vdd row_drive sar_comparator_input
+ decision_p decision_n reset eval latch_sense_p_ext iso_tail_ext tail_ext vdd_ext
+ vss_escape_uq1
Xphysical_preamp_n physical_preamp_n/preamp_iso_tail_ext physical_preamp_n/latch_sense_n_ext
+ physical_preamp_n/sar_comparator_input vss_escape_uq1 preamp_n_parent_bound
Xphysical_preamp_p physical_preamp_p/preamp_iso_tail_ext physical_preamp_p/latch_sense_p_ext
+ physical_preamp_p/row_drive vss_escape_uq1 preamp_p_parent_bound
Xconverter_latch_0 decision_p decision_n latch_sense_p_ext latch_sense_p_ext tail_ext
+ reset vdd_ext vss_escape_uq1 eval row_drive sar_comparator_input iso_tail_ext vdd_ext
+ escaped_input_latch
C0 shared_converter_mux_0/vdd vdd_ext 0
C1 row_drive vdd_ext 3.74725f
C2 tail_ext eval 0.01085f
C3 latch_sense_n_ext sar_comparator_input_uq0 0.01518f
C4 latch_sense_p_ext m4_51060_36440# 0.00643f
C5 row_drive sar_comparator_input 5.22878f
C6 vss vdd_ext 0.19458f
C7 shared_converter_mux_0/vdd shared_converter_mux_0/mux_bus 1.55306f
C8 row_drive shared_converter_mux_0/mux_bus 0.06281f
C9 row_drive sar_comparator_input_uq0 0.12269f
C10 vss shared_converter_mux_0/mux_bus 0.03132f
C11 row_drive row_dac_10b_0/vss 1.08123f
C12 iso_tail_ext vdd_ext 0.86179f
C13 sar_readout_12b_0/vdd vdd_ext 1.39936f
C14 sar_comparator_input iso_tail_ext 0.05996f
C15 m4_51060_36440# vdd_ext 0.01404f
C16 reset latch_sense_p_ext 0.19529f
C17 m4_45060_36440# latch_sense_p_ext 0.05112f
C18 decision_n latch_sense_p_ext 0.19207f
C19 row_drive sar_readout_12b_0/vss 0.29433f
C20 m4_51060_36440# sar_comparator_input_uq0 0.09574f
C21 row_drive m1_68300_3080# 2.68328f
C22 latch_sense_p_ext vdd_ext 10.05596f
C23 reset vdd_ext 0.01669f
C24 row_drive shared_converter_mux_0/vss 0.00246f
C25 m4_45060_36440# vdd_ext 0.01404f
C26 sar_readout_12b_0/vss iso_tail_ext 0.60045f
C27 sar_comparator_input latch_sense_p_ext -0.1861f
C28 sar_readout_12b_0/vss sar_readout_12b_0/vdd 0.49712f
C29 decision_p tail_ext 0.01085f
C30 eval latch_sense_p_ext 0.19752f
C31 row_dac_10b_0/vss row_dac_10b_0/vdd 0.78467f
C32 latch_sense_p_ext sar_comparator_input_uq0 0.29678f
C33 row_drive shared_converter_mux_0/vdd 0.00246f
C34 vss shared_converter_mux_0/vdd 0.2816f
C35 row_drive vss 0.22445f
C36 sar_comparator_input vdd_ext 1.06679f
C37 eval vdd_ext 0
C38 shared_converter_mux_0/mux_bus vdd_ext 0.00217f
C39 vdd row_drive 0.1964f
C40 sar_comparator_input_uq0 vdd_ext 0.0023f
C41 row_drive iso_tail_ext 2.13599f
C42 row_drive sar_readout_12b_0/vdd 0.58157f
C43 latch_sense_n_ext latch_sense_p_ext 0.04594f
C44 sar_readout_12b_0/vss vdd_ext 0.93663f
C45 iso_tail_ext sar_readout_12b_0/vdd 0.27521f
C46 tail_ext latch_sense_p_ext 2.0251f
C47 tail_ext reset 0.01085f
C48 decision_p latch_sense_p_ext 0.19207f
C49 row_drive row_dac_10b_0/vdd 1.11462f
C50 m1_68300_3080# vdd_ext 0.24419f
C51 tail_ext decision_n 0.01085f
C52 row_drive latch_sense_p_ext 1.70037f
C53 shared_converter_mux_0/vss vdd_ext 0
C54 row_drive m4_45060_36440# 0.0946f
C55 vss latch_sense_p_ext 0.58074f
C56 latch_sense_n_ext vdd_ext 0.00495f
C57 shared_converter_mux_0/vss shared_converter_mux_0/mux_bus 1.56188f
C58 decision_p vdd_ext 0
C59 latch_sense_p_ext iso_tail_ext -0.15827f
C60 vss vss_escape_uq1 36.7f
C61 vdd vss_escape_uq1 36.7f
C62 m4_51060_36440# vss_escape_uq1 0.12404f **FLOATING
C63 m4_45060_36440# vss_escape_uq1 0.10202f **FLOATING
C64 sar_comparator_input_uq0 vss_escape_uq1 6.44808f **FLOATING
C65 m1_68300_3080# vss_escape_uq1 7.89552f **FLOATING
C66 latch_sense_n_ext vss_escape_uq1 0.36632f **FLOATING
C67 iso_tail_ext vss_escape_uq1 -1.23816f
C68 sar_comparator_input vss_escape_uq1 11.80296f
C69 latch_sense_p_ext vss_escape_uq1 34.42644f
C70 decision_n vss_escape_uq1 3.8093f
C71 eval vss_escape_uq1 0.78348f
C72 row_drive vss_escape_uq1 49.4783f
C73 vdd_ext vss_escape_uq1 40.56003f
.ends
