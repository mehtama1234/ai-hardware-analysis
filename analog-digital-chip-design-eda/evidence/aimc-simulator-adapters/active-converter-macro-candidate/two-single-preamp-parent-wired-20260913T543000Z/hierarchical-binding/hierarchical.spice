* SPICE3 file created from aimc_converter_macro_active_candidate.ext - technology: sky130A

.subckt preamp_n_parent_bound preamp_iso_tail_ext latch_sense_n_ext sar_comparator_input
+ vss_escape
X0 latch_sense_n_ext a_2720_400# preamp_iso_tail_ext vss_escape sky130_fd_pr__nfet_01v8 ad=3.36 pd=8 as=3.12 ps=7.6 w=1.2 l=0.6
X1 latch_sense_n_ext sar_comparator_input preamp_iso_tail_ext vss_escape sky130_fd_pr__nfet_01v8 ad=3.36 pd=8 as=3.12 ps=7.6 w=1.2 l=0.6
C0 latch_sense_n_ext sar_comparator_input 0.06732f
C1 latch_sense_n_ext preamp_iso_tail_ext 0.17396f
C2 sar_comparator_input preamp_iso_tail_ext 0.15588f
C3 latch_sense_n_ext a_2720_400# 0.06991f
C4 a_2720_400# sar_comparator_input 0.13362f
C5 a_2720_400# preamp_iso_tail_ext 0.04002f
C6 latch_sense_n_ext vss_escape 4.67824f
C7 preamp_iso_tail_ext vss_escape 3.46609f
.ends

.subckt preamp_p_parent_bound preamp_iso_tail_ext latch_sense_p_ext row_drive vss_escape
X0 latch_sense_p_ext a_2720_400# preamp_iso_tail_ext vss_escape sky130_fd_pr__nfet_01v8 ad=3.36 pd=8 as=3.12 ps=7.6 w=1.2 l=0.6
X1 latch_sense_p_ext row_drive preamp_iso_tail_ext vss_escape sky130_fd_pr__nfet_01v8 ad=3.36 pd=8 as=3.12 ps=7.6 w=1.2 l=0.6
C0 preamp_iso_tail_ext row_drive 0.15588f
C1 a_2720_400# row_drive 0.13362f
C2 preamp_iso_tail_ext a_2720_400# 0.04002f
C3 latch_sense_p_ext row_drive 0.06732f
C4 preamp_iso_tail_ext latch_sense_p_ext 0.17396f
C5 a_2720_400# latch_sense_p_ext 0.06991f
C6 latch_sense_p_ext vss_escape 4.67824f
C7 preamp_iso_tail_ext vss_escape 3.46609f
.ends

.subckt escaped_input_latch out_p out_n latch_sense_p latch_sense_n tail reset vdd
+ vss eval sense_p sense_n iso_tail vdd_active
X0 out_p out_n vdd_active vdd_active sky130_fd_pr__pfet_01v8 ad=3.36 pd=8 as=3.12 ps=7.6 w=1.2 l=0.6
X1 vdd reset out_n vdd sky130_fd_pr__pfet_01v8 ad=3.12 pd=7.6 as=3.36 ps=8 w=1.2 l=0.6
X2 tail out_p out_n vss sky130_fd_pr__nfet_01v8 ad=3.12 pd=7.6 as=3.36 ps=8 w=1.2 l=0.6
X3 out_p reset vdd vdd sky130_fd_pr__pfet_01v8 ad=3.36 pd=8 as=3.12 ps=7.6 w=1.2 l=0.6
X4 out_p out_n tail vss sky130_fd_pr__nfet_01v8 ad=3.36 pd=8 as=3.12 ps=7.6 w=1.2 l=0.6
X5 tail latch_sense_n out_n vss sky130_fd_pr__nfet_01v8 ad=3.12 pd=7.6 as=3.36 ps=8 w=1.2 l=0.6
X6 tail eval vss vss sky130_fd_pr__nfet_01v8 ad=16.2 pd=17.4 as=16.2 ps=17.4 w=6 l=0.6
X7 out_p latch_sense_p tail vss sky130_fd_pr__nfet_01v8 ad=3.36 pd=8 as=3.12 ps=7.6 w=1.2 l=0.6
X8 iso_tail sense_n latch_sense_n vss sky130_fd_pr__nfet_01v8 ad=3.12 pd=7.6 as=3.36 ps=8 w=1.2 l=0.6
X9 vdd_active out_p out_n vdd_active sky130_fd_pr__pfet_01v8 ad=3.12 pd=7.6 as=3.36 ps=8 w=1.2 l=0.6
X10 latch_sense_p sense_p iso_tail vss sky130_fd_pr__nfet_01v8 ad=3.36 pd=8 as=3.12 ps=7.6 w=1.2 l=0.6
C0 latch_sense_p tail 0.0334f
C1 iso_tail sense_p 0.26105f
C2 tail out_p 0.46979f
C3 tail vdd 0.9918f
C4 iso_tail latch_sense_n 0.20888f
C5 out_n vdd_active 3.16716f
C6 tail reset 0.16491f
C7 vdd_active out_p 3.06556f
C8 out_n out_p 2.54301f
C9 sense_n latch_sense_n 0.22977f
C10 out_n vdd 0.77104f
C11 out_n reset 0.31048f
C12 latch_sense_p out_p 0.18428f
C13 vdd out_p 0.76206f
C14 reset out_p 0.376f
C15 latch_sense_p iso_tail 0.20888f
C16 vdd reset 4.47121f
C17 tail latch_sense_n 0.0334f
C18 out_n latch_sense_n 0.18428f
C19 sense_n iso_tail 0.10725f
C20 tail vdd_active 0.9938f
C21 eval tail 0.35666f
C22 latch_sense_p sense_p 0.22977f
C23 out_n tail 0.46979f
C24 iso_tail vss 29.23796f
C25 latch_sense_n vss 1.7693f
C26 latch_sense_p vss 1.56796f
C27 out_n vss 13.58747f
C28 tail vss 89.03816f
C29 vdd_active vss 90.11912f
C30 vdd vss 78.65506f
.ends

.subckt aimc_converter_macro_active_candidate vss vdd row_drive sar_comparator_input
+ decision_p decision_n reset eval latch_sense_p_ext latch_sense_n_ext iso_tail_ext
+ tail_ext vdd_ext preamp_iso_tail_ext vss_escape_uq1
Xphysical_preamp_n physical_preamp_n/preamp_iso_tail_ext physical_preamp_n/latch_sense_n_ext
+ physical_preamp_n/sar_comparator_input vss_escape_uq1 preamp_n_parent_bound
Xphysical_preamp_p physical_preamp_p/preamp_iso_tail_ext physical_preamp_p/latch_sense_p_ext
+ physical_preamp_p/row_drive vss_escape_uq1 preamp_p_parent_bound
Xconverter_latch_0 decision_p decision_n latch_sense_p_ext latch_sense_n_ext tail_ext
+ reset vdd_ext vss_escape_uq1 eval row_drive sar_comparator_input iso_tail_ext vdd_ext
+ escaped_input_latch
C0 decision_p tail_ext 0.01085f
C1 decision_n latch_sense_n_ext 0.19207f
C2 vdd_ext sar_readout_12b_0/vss 0.93663f
C3 m4_45060_36440# latch_sense_p_ext 0.00631f
C4 m1_68300_3080# row_drive 2.68328f
C5 preamp_iso_tail_ext latch_sense_p_ext 0.17162f
C6 iso_tail_ext latch_sense_n_ext -0.07889f
C7 vss row_drive 0.22445f
C8 eval tail_ext 0.01085f
C9 iso_tail_ext latch_sense_p_ext -0.07937f
C10 reset tail_ext 0.01085f
C11 m4_45060_36440# row_drive 0.07138f
C12 preamp_iso_tail_ext row_drive 0.00432f
C13 vdd_ext sar_comparator_input 1.72288f
C14 row_dac_10b_0/vss row_drive 1.08123f
C15 vdd_ext shared_converter_mux_0/vss 0
C16 decision_n tail_ext 0.01085f
C17 row_drive iso_tail_ext 2.13599f
C18 sar_comparator_input latch_sense_n_ext 0.39015f
C19 sar_readout_12b_0/vdd iso_tail_ext 0.27521f
C20 sar_readout_12b_0/vss row_drive 0.29433f
C21 sar_readout_12b_0/vss sar_readout_12b_0/vdd 0.49712f
C22 m4_32000_38940# latch_sense_n_ext 0.0096f
C23 sar_comparator_input latch_sense_p_ext 0.07904f
C24 shared_converter_mux_0/vss shared_converter_mux_0/mux_bus 1.56188f
C25 m4_32000_38940# latch_sense_p_ext 0.00354f
C26 vdd_ext latch_sense_n_ext 4.54014f
C27 vdd_ext shared_converter_mux_0/mux_bus 0.00217f
C28 sar_comparator_input row_drive 5.4563f
C29 vdd_ext latch_sense_p_ext 5.37086f
C30 vdd_ext shared_converter_mux_0/vdd 0
C31 shared_converter_mux_0/vss row_drive 0.00246f
C32 row_dac_10b_0/vdd row_drive 1.11462f
C33 m1_68300_3080# sar_comparator_input 0.05195f
C34 latch_sense_p_ext latch_sense_n_ext 0.58447f
C35 vss sar_comparator_input 0.05708f
C36 shared_converter_mux_0/vdd shared_converter_mux_0/mux_bus 1.55306f
C37 sar_readout_12b_0/vss iso_tail_ext 0.60045f
C38 vdd row_drive 0.1964f
C39 vdd_ext decision_p 0
C40 vdd_ext row_drive 4.95644f
C41 vdd_ext sar_readout_12b_0/vdd 1.39936f
C42 m4_45060_36440# sar_comparator_input 0.05954f
C43 sar_comparator_input preamp_iso_tail_ext 0.01404f
C44 row_drive latch_sense_n_ext 0.79612f
C45 sar_comparator_input decision_n 0.17131f
C46 vdd_ext m1_68300_3080# 0.24419f
C47 row_drive shared_converter_mux_0/mux_bus 0.06281f
C48 vdd_ext eval 0
C49 vss vdd_ext 0.19458f
C50 decision_p latch_sense_p_ext 0.19207f
C51 tail_ext latch_sense_n_ext 1.06262f
C52 row_drive latch_sense_p_ext 1.03568f
C53 row_drive shared_converter_mux_0/vdd 0.00246f
C54 sar_comparator_input iso_tail_ext 0.05996f
C55 vdd_ext reset 0.01669f
C56 row_dac_10b_0/vdd row_dac_10b_0/vss 0.78467f
C57 row_drive m2_42000_41940# 0.12051f
C58 vss latch_sense_n_ext 0.29037f
C59 tail_ext latch_sense_p_ext 0.96249f
C60 vss shared_converter_mux_0/mux_bus 0.03132f
C61 vdd_ext m4_45060_36440# 0.01404f
C62 vdd_ext preamp_iso_tail_ext 0.00145f
C63 eval latch_sense_p_ext 0.19752f
C64 vss latch_sense_p_ext 0.29037f
C65 vss shared_converter_mux_0/vdd 0.2816f
C66 row_drive sar_readout_12b_0/vdd 0.58157f
C67 reset latch_sense_p_ext 0.19529f
C68 preamp_iso_tail_ext latch_sense_n_ext 0.25914f
C69 vdd_ext iso_tail_ext 0.86179f
C70 vss vss_escape_uq1 36.7f
C71 preamp_iso_tail_ext vss_escape_uq1 4.44855f
C72 vdd vss_escape_uq1 36.7f
C73 m4_45060_36440# vss_escape_uq1 0.09654f **FLOATING
C74 m4_32000_38940# vss_escape_uq1 0.1568f **FLOATING
C75 m2_42000_41940# vss_escape_uq1 3.91591f **FLOATING
C76 m1_68300_3080# vss_escape_uq1 7.89552f **FLOATING
C77 iso_tail_ext vss_escape_uq1 -1.23816f
C78 sar_comparator_input vss_escape_uq1 29.28228f
C79 latch_sense_n_ext vss_escape_uq1 8.3977f
C80 latch_sense_p_ext vss_escape_uq1 11.20863f
C81 decision_n vss_escape_uq1 3.8093f
C82 eval vss_escape_uq1 0.78348f
C83 row_drive vss_escape_uq1 65.2568f
C84 vdd_ext vss_escape_uq1 40.12473f
.ends
