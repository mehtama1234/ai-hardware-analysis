* NGSPICE file created from aimc_converter_macro_active_candidate_flat.ext - technology: sky130A

.subckt aimc_converter_macro_active_candidate_flat vss vdd row_drive sar_comparator_input
+ decision_p decision_n reset eval vss_escape latch_sense_p_ext latch_sense_n_ext
+ iso_tail_ext tail_ext vdd_ext
X0 physical_preamp_0.iso_tail physical_preamp_0.sense_n physical_preamp_0.iso_n vss_escape sky130_fd_pr__nfet_01v8 ad=3.12 pd=7.6 as=3.36 ps=8 w=1.2 l=0.6
X1 vdd_ext decision_p decision_n vdd_ext sky130_fd_pr__pfet_01v8 ad=3.12 pd=7.6 as=3.36 ps=8 w=1.2 l=0.6
X2 tail_ext eval vss_escape vss_escape sky130_fd_pr__nfet_01v8 ad=16.2 pd=17.4 as=16.2 ps=17.4 w=6 l=0.6
X3 physical_preamp_0.iso_p physical_preamp_0.sense_p physical_preamp_0.iso_tail vss_escape sky130_fd_pr__nfet_01v8 ad=3.36 pd=8 as=3.12 ps=7.6 w=1.2 l=0.6
X4 decision_p latch_sense_p_ext tail_ext vss_escape sky130_fd_pr__nfet_01v8 ad=3.36 pd=8 as=3.12 ps=7.6 w=1.2 l=0.6
X5 vdd_ext reset decision_n vdd_ext sky130_fd_pr__pfet_01v8 ad=3.12 pd=7.6 as=3.36 ps=8 w=1.2 l=0.6
X6 tail_ext latch_sense_n_ext decision_n vss_escape sky130_fd_pr__nfet_01v8 ad=3.12 pd=7.6 as=3.36 ps=8 w=1.2 l=0.6
X7 decision_p decision_n vdd_ext vdd_ext sky130_fd_pr__pfet_01v8 ad=3.36 pd=8 as=3.12 ps=7.6 w=1.2 l=0.6
X8 tail_ext decision_p decision_n vss_escape sky130_fd_pr__nfet_01v8 ad=3.12 pd=7.6 as=3.36 ps=8 w=1.2 l=0.6
X9 latch_sense_p_ext row_drive iso_tail_ext vss_escape sky130_fd_pr__nfet_01v8 ad=3.36 pd=8 as=3.12 ps=7.6 w=1.2 l=0.6
X10 iso_tail_ext sar_comparator_input latch_sense_n_ext vss_escape sky130_fd_pr__nfet_01v8 ad=3.12 pd=7.6 as=3.36 ps=8 w=1.2 l=0.6
X11 decision_p reset vdd_ext vdd_ext sky130_fd_pr__pfet_01v8 ad=3.36 pd=8 as=3.12 ps=7.6 w=1.2 l=0.6
X12 decision_p decision_n tail_ext vss_escape sky130_fd_pr__nfet_01v8 ad=3.36 pd=8 as=3.12 ps=7.6 w=1.2 l=0.6
C0 sar_comparator_input row_drive 5.24644f
C1 li_67560_3080# row_drive 2.7609f
C2 vdd_ext sar_readout_12b_0.vdd 1.39936f
C3 sar_comparator_input latch_sense_n_ext 0.04279f
C4 physical_preamp_0.iso_n physical_preamp_0.iso_tail 0.05717f
C5 vdd_ext physical_preamp_0.sense_p 0.04069f
C6 vdd_ext vss 0.21361f
C7 physical_preamp_0.iso_n physical_preamp_0.iso_p 0.00782f
C8 sar_readout_12b_0.vdd sar_readout_12b_0.vss 0.49712f
C9 row_drive latch_sense_p_ext 0.6214f
C10 physical_preamp_0.sense_n sar_comparator_input 0.07548f
C11 li_67560_3080# physical_preamp_0.sense_n 0.10132f
C12 vdd_ext decision_p 3.8282f
C13 tail_ext latch_sense_n_ext 0.0334f
C14 vdd_ext sar_comparator_input 1.05718f
C15 physical_preamp_0.iso_tail physical_preamp_0.iso_p 0.05749f
C16 vdd_ext li_67560_3080# 0.56463f
C17 shared_converter_mux_0.mux_bus row_drive 0.06281f
C18 vdd_ext tail_ext 1.9856f
C19 physical_preamp_0.iso_n m2_64900_1400# 0.41846f
C20 shared_converter_mux_0.vss row_drive 0.00246f
C21 eval tail_ext 0.36751f
C22 vdd_ext latch_sense_p_ext 3.43095f
C23 physical_preamp_0.sense_p sar_comparator_input 0.04049f
C24 physical_preamp_0.sense_p li_67560_3080# 0
C25 physical_preamp_0.iso_tail m2_64900_1400# 0.34398f
C26 physical_preamp_0.iso_p m2_64900_1400# 0.41846f
C27 vss latch_sense_p_ext 0.23329f
C28 vdd_ext shared_converter_mux_0.mux_bus 0.00217f
C29 vdd_ext reset 4.48789f
C30 shared_converter_mux_0.vss vdd_ext 0
C31 physical_preamp_0.iso_n row_drive 0.00494f
C32 shared_converter_mux_0.vdd row_drive 0.00246f
C33 tail_ext decision_p 0.48065f
C34 latch_sense_p_ext decision_p 0.18428f
C35 row_dac_10b_0.vss row_drive 1.08123f
C36 latch_sense_n_ext decision_n 0.18428f
C37 row_drive iso_tail_ext 2.39704f
C38 physical_preamp_0.iso_tail row_drive 0.38216f
C39 shared_converter_mux_0.mux_bus vss 0.03132f
C40 physical_preamp_0.iso_p row_drive 0.00627f
C41 physical_preamp_0.iso_n physical_preamp_0.sense_n 0.02157f
C42 latch_sense_n_ext iso_tail_ext 0.12577f
C43 tail_ext latch_sense_p_ext 0.0334f
C44 row_dac_10b_0.vss row_dac_10b_0.vdd 0.78467f
C45 physical_preamp_0.iso_n vdd_ext 0.0106f
C46 vdd_ext decision_n 3.9382f
C47 vdd_ext shared_converter_mux_0.vdd 0
C48 decision_p reset 0.376f
C49 physical_preamp_0.sense_n physical_preamp_0.iso_tail 0.12781f
C50 vdd_ext iso_tail_ext 0.86179f
C51 vdd_ext physical_preamp_0.iso_tail 0.29181f
C52 sar_readout_12b_0.vss iso_tail_ext 0.60045f
C53 vdd_ext physical_preamp_0.iso_p 0.02484f
C54 m2_64900_1400# row_drive 0.01775f
C55 tail_ext reset 0.17577f
C56 shared_converter_mux_0.vdd vss 0.2816f
C57 sar_readout_12b_0.vdd iso_tail_ext 0.27521f
C58 decision_n decision_p 2.54301f
C59 physical_preamp_0.iso_n sar_comparator_input 0.0285f
C60 physical_preamp_0.sense_p physical_preamp_0.iso_tail 0.13895f
C61 physical_preamp_0.sense_n m2_64900_1400# 0.04189f
C62 physical_preamp_0.sense_p physical_preamp_0.iso_p 0.02157f
C63 physical_preamp_0.iso_n li_67560_3080# 0
C64 vdd row_drive 0.1964f
C65 vdd_ext m2_64900_1400# 0.07196f
C66 sar_comparator_input iso_tail_ext 0.16721f
C67 shared_converter_mux_0.vss shared_converter_mux_0.mux_bus 1.56188f
C68 physical_preamp_0.iso_tail sar_comparator_input 0.03759f
C69 tail_ext decision_n 0.48065f
C70 physical_preamp_0.iso_p sar_comparator_input 0.02717f
C71 li_67560_3080# physical_preamp_0.iso_tail 0.00653f
C72 li_67560_3080# physical_preamp_0.iso_p 0
C73 latch_sense_n_ext row_drive 0.57746f
C74 iso_tail_ext latch_sense_p_ext 0.12577f
C75 physical_preamp_0.sense_n row_drive 0.09115f
C76 physical_preamp_0.sense_p m2_64900_1400# 0.03788f
C77 row_dac_10b_0.vdd row_drive 1.11462f
C78 vdd_ext row_drive 4.15084f
C79 shared_converter_mux_0.mux_bus shared_converter_mux_0.vdd 1.55306f
C80 decision_n reset 0.31048f
C81 sar_readout_12b_0.vss row_drive 0.29433f
C82 sar_comparator_input m2_64900_1400# 0.1759f
C83 vdd_ext latch_sense_n_ext 3.48444f
C84 li_67560_3080# m2_64900_1400# 0
C85 vdd_ext physical_preamp_0.sense_n 0.01232f
C86 sar_readout_12b_0.vdd row_drive 0.58157f
C87 physical_preamp_0.sense_p row_drive 0.19241f
C88 vss row_drive 0.22445f
C89 eval vdd_ext 0
C90 vss latch_sense_n_ext 0.23329f
C91 vdd_ext sar_readout_12b_0.vss 0.93663f
C92 vss vss_escape 36.2211f
C93 vdd vss_escape 36.7f
C94 iso_tail_ext vss_escape 66.3124f
C95 latch_sense_n_ext vss_escape 8.9128f
C96 latch_sense_p_ext vss_escape 36.4314f
C97 decision_p vss_escape 7.38983f
C98 tail_ext vss_escape 81.08725f
C99 vdd_ext vss_escape 0.25873p
C100 m2_64900_1400# vss_escape 0.71003f ; **FLOATING
C101 sar_readout_12b_0.vss vss_escape 1.33686f ; **FLOATING
C102 row_dac_10b_0.vss vss_escape 1.40333f ; **FLOATING
C103 row_dac_10b_0.vdd vss_escape 1.33457f ; **FLOATING
C104 sar_readout_12b_0.vdd vss_escape 1.77614f ; **FLOATING
C105 shared_converter_mux_0.vss vss_escape 1.39454f ; **FLOATING
C106 shared_converter_mux_0.mux_bus vss_escape 2.86922f ; **FLOATING
C107 shared_converter_mux_0.vdd vss_escape 0.95985f ; **FLOATING
C108 li_67560_3080# vss_escape 8.17525f ; **FLOATING
C109 physical_preamp_0.iso_n vss_escape 1.39478f
C110 physical_preamp_0.iso_p vss_escape 1.22056f
C111 physical_preamp_0.iso_tail vss_escape 4.3757f
.ends
