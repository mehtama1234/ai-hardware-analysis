* NGSPICE file created from aimc_converter_macro_active_candidate_flat.ext - technology: sky130A

.subckt aimc_converter_macro_active_candidate_flat
X0 physical_preamp_n.latch_sense_n_ext sar_comparator_input row_drive row_drive sky130_fd_pr__nfet_01v8 ad=3.36 pd=8 as=3.12 ps=7.6 w=1.2 l=0.6
X1 converter_latch_0.vdd_active row_drive row_drive converter_latch_0.vdd_active sky130_fd_pr__pfet_01v8 ad=3.12 pd=7.6 as=3.36 ps=8 w=1.2 l=0.6
X2 converter_latch_0.tail row_drive row_drive row_drive sky130_fd_pr__nfet_01v8 ad=16.2 pd=17.4 as=16.2 ps=17.4 w=6 l=0.6
X3 row_drive row_drive converter_latch_0.tail row_drive sky130_fd_pr__nfet_01v8 ad=3.36 pd=8 as=3.12 ps=7.6 w=1.2 l=0.6
X4 w_25600_24300# row_drive row_drive w_25600_24300# sky130_fd_pr__pfet_01v8 ad=3.12 pd=7.6 as=3.36 ps=8 w=1.2 l=0.6
X5 converter_latch_0.tail latch_sense_n_ext row_drive row_drive sky130_fd_pr__nfet_01v8 ad=3.12 pd=7.6 as=3.36 ps=8 w=1.2 l=0.6
X6 row_drive row_drive converter_latch_0.vdd_active converter_latch_0.vdd_active sky130_fd_pr__pfet_01v8 ad=3.36 pd=8 as=3.12 ps=7.6 w=1.2 l=0.6
X7 converter_latch_0.tail row_drive row_drive row_drive sky130_fd_pr__nfet_01v8 ad=3.12 pd=7.6 as=3.36 ps=8 w=1.2 l=0.6
X8 row_drive converter_latch_0.sense_p a_12600_1380# row_drive sky130_fd_pr__nfet_01v8 ad=3.36 pd=8 as=3.12 ps=7.6 w=1.2 l=0.6
X9 a_26880_1380# converter_latch_0.sense_n latch_sense_n_ext row_drive sky130_fd_pr__nfet_01v8 ad=3.12 pd=7.6 as=3.36 ps=8 w=1.2 l=0.6
X10 row_drive row_drive row_drive row_drive sky130_fd_pr__nfet_01v8 ad=3.12 pd=7.6 as=42.6 ps=80.6 w=1.2 l=0.6
X11 row_drive row_drive a_12600_25380# converter_latch_0.vdd sky130_fd_pr__pfet_01v8 ad=3.36 pd=8 as=3.12 ps=7.6 w=1.2 l=0.6
X12 row_drive row_drive converter_latch_0.tail row_drive sky130_fd_pr__nfet_01v8 ad=3.36 pd=8 as=3.12 ps=7.6 w=1.2 l=0.6
C0 converter_latch_0.vdd_active converter_latch_0.tail 0.9938f
C1 physical_preamp_n.latch_sense_n_ext latch_sense_n_ext 0.06206f
C2 converter_latch_0.sense_n latch_sense_n_ext 0.22977f
C3 converter_latch_0.tail a_12600_25380# 0.15683f
C4 a_26880_1380# converter_latch_0.sense_n 0.0886f
C5 sar_comparator_input latch_sense_n_ext 0.15789f
C6 converter_latch_0.vdd a_12600_25380# 1.24906f
C7 w_25600_24300# converter_latch_0.tail 0.67871f
C8 w_25600_24300# converter_latch_0.vdd 0.71614f
C9 converter_latch_0.tail latch_sense_n_ext 0.23156f
C10 sar_comparator_input physical_preamp_n.latch_sense_n_ext 0.07067f
C11 w_25600_24300# a_12600_25380# 0.02838f
C12 converter_latch_0.vdd_active latch_sense_n_ext 0.19816f
C13 w_25600_24300# latch_sense_n_ext 0.19816f
C14 a_26880_1380# latch_sense_n_ext 0.20888f
C15 converter_latch_0.vdd converter_latch_0.tail 0.15626f
C16 a_12600_1380# converter_latch_0.sense_p 0.0886f
C17 m5_47800_47940# row_drive 0.2096f ; **FLOATING
C18 a_26880_1380# row_drive 5.95149f
C19 a_12600_1380# row_drive 6.27526f
C20 latch_sense_n_ext row_drive 1.79101f
C21 a_12600_25380# row_drive 2.97705f
C22 converter_latch_0.tail row_drive 67.96335f
C23 physical_preamp_n.latch_sense_n_ext row_drive 13.45939f
C24 converter_latch_0.vdd_active row_drive 92.79925f
C25 w_25600_24300# row_drive 47.9501f
C26 converter_latch_0.vdd row_drive 27.355f
.ends
