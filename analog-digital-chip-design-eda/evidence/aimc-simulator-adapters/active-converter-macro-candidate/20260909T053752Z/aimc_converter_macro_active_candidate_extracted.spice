* NGSPICE file created from aimc_converter_macro_active_candidate.ext - technology: sky130A

.subckt sky130_isolated_frontend_active_load_latch_v2 out_p out_n latch_sense_p latch_sense_n
+ tail reset vdd vss eval sense_p sense_n iso_tail vdd_active
X0 latch_sense_p sense_p iso_tail vss sky130_fd_pr__nfet_01v8 ad=3.36 pd=8 as=3.12 ps=7.6 w=1.2 l=0.6
X1 out_p out_n tail vss sky130_fd_pr__nfet_01v8 ad=3.36 pd=8 as=3.12 ps=7.6 w=1.2 l=0.6
X2 out_n latch_sense_n tail vss sky130_fd_pr__nfet_01v8 ad=3.36 pd=8 as=3.12 ps=7.6 w=1.2 l=0.6
X3 out_n out_p vdd_active vdd_active sky130_fd_pr__pfet_01v8 ad=3.36 pd=8 as=3.12 ps=7.6 w=1.2 l=0.6
X4 iso_tail sense_n latch_sense_n vss sky130_fd_pr__nfet_01v8 ad=3.12 pd=7.6 as=3.36 ps=8 w=1.2 l=0.6
X5 out_n out_p tail vss sky130_fd_pr__nfet_01v8 ad=3.36 pd=8 as=3.12 ps=7.6 w=1.2 l=0.6
X6 out_n reset vdd vdd sky130_fd_pr__pfet_01v8 ad=3.36 pd=8 as=3.12 ps=7.6 w=1.2 l=0.6
X7 out_p latch_sense_p tail vss sky130_fd_pr__nfet_01v8 ad=3.36 pd=8 as=3.12 ps=7.6 w=1.2 l=0.6
X8 tail eval vss vss sky130_fd_pr__nfet_01v8 ad=16.8 pd=17.6 as=15.6 ps=17.2 w=6 l=0.6
X9 out_p out_n vdd_active vdd_active sky130_fd_pr__pfet_01v8 ad=3.36 pd=8 as=3.12 ps=7.6 w=1.2 l=0.6
X10 out_p reset vdd vdd sky130_fd_pr__pfet_01v8 ad=3.36 pd=8 as=3.12 ps=7.6 w=1.2 l=0.6
C0 latch_sense_p vdd_active 0.50449f
C1 eval out_n 0.02298f
C2 out_p eval 0.04062f
C3 latch_sense_p iso_tail 0.09804f
C4 out_n vdd_active 5.52673f
C5 latch_sense_p out_n 0.27084f
C6 latch_sense_p sense_p 0.06485f
C7 reset out_n 0.05967f
C8 out_p vdd_active 4.31746f
C9 latch_sense_p out_p 0.32159f
C10 sense_p iso_tail 0.12292f
C11 reset out_p 0.07615f
C12 out_p out_n 1.85382f
C13 latch_sense_n vdd_active 0.53393f
C14 iso_tail sense_n 0.11179f
C15 latch_sense_p latch_sense_n 0.0207f
C16 tail eval 0.09415f
C17 latch_sense_n iso_tail 0.15122f
C18 reset vdd 4.28849f
C19 latch_sense_n out_n 1.04924f
C20 latch_sense_p tail 0.36163f
C21 out_p latch_sense_n 1.00043f
C22 out_n vdd 0.95698f
C23 latch_sense_n sense_n 0.05507f
C24 out_p vdd 1.0487f
C25 tail out_n 2.28538f
C26 latch_sense_p m1_1000_12500# 0.05106f
C27 iso_tail m1_3440_12500# 0.00302f
C28 out_p tail 3.33055f
C29 iso_tail m1_1000_12500# 0.00302f
C30 sense_p m1_1000_12500# 0.04904f
C31 sense_n m1_3440_12500# 0.04904f
C32 tail latch_sense_n 0.4349f
C33 latch_sense_n m1_3440_12500# 0.0106f
C34 tail vss 27.29601f
C35 out_p vss 12.23545f
C36 latch_sense_n vss 0.71261f
C37 iso_tail vss 4.24257f
C38 vdd vss 31.12f
C39 vdd_active vss 65.63497f
C40 m1_3440_12500# vss 0.33861f ; **FLOATING
C41 m1_1000_12500# vss 0.33861f ; **FLOATING
.ends

.subckt aimc_converter_macro_active_candidate vss vdd row_drive column_sense
Xconverter_latch_0 column_sense column_sense column_sense column_sense vss converter_latch_0/reset
+ converter_latch_0/vdd vss converter_latch_0/eval converter_latch_0/sense_p converter_latch_0/sense_n
+ converter_latch_0/iso_tail converter_latch_0/vdd_active sky130_isolated_frontend_active_load_latch_v2
C0 column_sense row_drive 0.26356f
C1 column_sense converter_latch_0/reset 0.16803f
C2 column_sense converter_latch_0/eval -0.00654f
C3 shared_converter_mux_0/vss row_drive 0.00246f
C4 column_sense shared_converter_mux_0/vss 1.56464f
C5 sar_readout_12b_0/vss row_drive 0.00137f
C6 column_sense sar_readout_12b_0/vss 1.26971f
C7 shared_converter_mux_0/vdd row_drive 0.00246f
C8 vdd row_drive 0.1964f
C9 row_drive row_dac_10b_0/vdd 1.11418f
C10 column_sense shared_converter_mux_0/vdd 1.55435f
C11 column_sense vdd 0.39279f
C12 row_dac_10b_0/vss row_drive 1.08123f
C13 sar_readout_12b_0/vdd row_drive 0.00142f
C14 column_sense sar_readout_12b_0/vdd 1.77858f
C15 converter_latch_0/reset converter_latch_0/vdd -0.11975f
C16 column_sense converter_latch_0/vdd 1.37911f
C17 sar_readout_12b_0/vdd sar_readout_12b_0/vss 0.53484f
C18 row_dac_10b_0/vss row_dac_10b_0/vdd 0.78467f
C19 vdd vss 22.6565f
C20 converter_latch_0/eval vss 0.05552f
C21 row_drive vss 20.36675f
C22 column_sense vss 55.43567f
C23 shared_converter_mux_0/vdd vss 0.2816f
.ends
