* NGSPICE file created from aimc_converter_macro_active_candidate_flat.ext - technology: sky130A

.subckt aimc_converter_macro_active_candidate_flat vss vdd row_drive sar_comparator_input
+ decision_p decision_n reset eval vss_escape latch_sense_p_ext latch_sense_n_ext
+ iso_tail_ext tail_ext vdd_ext
X0 latch_sense_n_ext physical_preamp_n.sar_comparator_input latch_sense_p_ext vss_escape sky130_fd_pr__nfet_01v8 ad=3.36 pd=8 as=3.12 ps=7.6 w=1.2 l=0.6
X1 vdd_ext decision_p decision_n vdd_ext sky130_fd_pr__pfet_01v8 ad=3.12 pd=7.6 as=3.36 ps=8 w=1.2 l=0.6
X2 tail_ext eval vss_escape vss_escape sky130_fd_pr__nfet_01v8 ad=16.2 pd=17.4 as=16.2 ps=17.4 w=6 l=0.6
X3 decision_p latch_sense_p_ext tail_ext vss_escape sky130_fd_pr__nfet_01v8 ad=3.36 pd=8 as=3.12 ps=7.6 w=1.2 l=0.6
X4 vdd_ext reset decision_n vdd_ext sky130_fd_pr__pfet_01v8 ad=3.12 pd=7.6 as=3.36 ps=8 w=1.2 l=0.6
X5 tail_ext latch_sense_n_ext decision_n vss_escape sky130_fd_pr__nfet_01v8 ad=3.12 pd=7.6 as=3.36 ps=8 w=1.2 l=0.6
X6 decision_p decision_n vdd_ext vdd_ext sky130_fd_pr__pfet_01v8 ad=3.36 pd=8 as=3.12 ps=7.6 w=1.2 l=0.6
X7 tail_ext decision_p decision_n vss_escape sky130_fd_pr__nfet_01v8 ad=3.12 pd=7.6 as=3.36 ps=8 w=1.2 l=0.6
X8 latch_sense_p_ext row_drive iso_tail_ext vss_escape sky130_fd_pr__nfet_01v8 ad=3.36 pd=8 as=3.12 ps=7.6 w=1.2 l=0.6
X9 iso_tail_ext sar_comparator_input latch_sense_n_ext vss_escape sky130_fd_pr__nfet_01v8 ad=3.12 pd=7.6 as=3.36 ps=8 w=1.2 l=0.6
X10 latch_sense_p_ext row_drive latch_sense_p_ext vss_escape sky130_fd_pr__nfet_01v8 ad=3.12 pd=7.6 as=12.96 ps=31.2 w=1.2 l=0.6
X11 decision_p reset vdd_ext vdd_ext sky130_fd_pr__pfet_01v8 ad=3.36 pd=8 as=3.12 ps=7.6 w=1.2 l=0.6
X12 decision_p decision_n tail_ext vss_escape sky130_fd_pr__nfet_01v8 ad=3.36 pd=8 as=3.12 ps=7.6 w=1.2 l=0.6
C0 sar_readout_12b_0.vdd iso_tail_ext 0.27521f
C1 shared_converter_mux_0.mux_bus row_drive 0.06281f
C2 decision_p latch_sense_p_ext 0.37635f
C3 shared_converter_mux_0.vdd vdd_ext 0
C4 shared_converter_mux_0.vss row_drive 0.00246f
C5 physical_preamp_n.sar_comparator_input m4_45060_36440# 0.00629f
C6 sar_readout_12b_0.vss vdd_ext 0.93663f
C7 eval latch_sense_p_ext 0.19752f
C8 latch_sense_n_ext sar_comparator_input 0.04367f
C9 latch_sense_n_ext latch_sense_p_ext 0.97625f
C10 m1_68300_3080# row_drive 2.68328f
C11 shared_converter_mux_0.mux_bus shared_converter_mux_0.vss 1.56188f
C12 m4_45060_36440# row_drive 0.10035f
C13 decision_n vdd_ext 3.9382f
C14 iso_tail_ext row_drive 2.39704f
C15 decision_n tail_ext 0.48065f
C16 m4_32000_38940# latch_sense_p_ext 0.00354f
C17 physical_preamp_n.sar_comparator_input latch_sense_n_ext 0.1507f
C18 m4_51060_36440# latch_sense_n_ext 0.00671f
C19 tail_ext vdd_ext 1.9856f
C20 sar_readout_12b_0.vdd sar_readout_12b_0.vss 0.49712f
C21 sar_comparator_input vdd_ext 1.06679f
C22 vss latch_sense_n_ext 0.29037f
C23 latch_sense_p_ext vdd_ext 5.39814f
C24 decision_p reset 0.376f
C25 tail_ext latch_sense_p_ext 0.99589f
C26 latch_sense_n_ext row_drive 0.83022f
C27 vss shared_converter_mux_0.vdd 0.2816f
C28 row_dac_10b_0.vdd row_dac_10b_0.vss 0.78467f
C29 shared_converter_mux_0.vdd row_drive 0.00246f
C30 sar_readout_12b_0.vss row_drive 0.29433f
C31 sar_readout_12b_0.vdd vdd_ext 1.39936f
C32 shared_converter_mux_0.vdd shared_converter_mux_0.mux_bus 1.55306f
C33 physical_preamp_n.sar_comparator_input vdd_ext 0.17176f
C34 m4_51060_36440# vdd_ext 0.01404f
C35 row_dac_10b_0.vss row_drive 1.08123f
C36 latch_sense_n_ext m4_45060_36440# 0.00655f
C37 physical_preamp_n.sar_comparator_input latch_sense_p_ext 0.18845f
C38 iso_tail_ext latch_sense_n_ext 0.12999f
C39 vss vdd_ext 0.19458f
C40 m4_51060_36440# latch_sense_p_ext 0.00179f
C41 decision_n reset 0.31048f
C42 row_drive vdd_ext 5.04789f
C43 sar_readout_12b_0.vss iso_tail_ext 0.60045f
C44 vdd row_drive 0.1964f
C45 reset vdd_ext 4.48789f
C46 tail_ext reset 0.17577f
C47 shared_converter_mux_0.mux_bus vdd_ext 0.00217f
C48 vss latch_sense_p_ext 0.29037f
C49 shared_converter_mux_0.vss vdd_ext 0
C50 sar_comparator_input row_drive 5.22878f
C51 latch_sense_p_ext row_drive 1.38569f
C52 physical_preamp_n.sar_comparator_input m4_51060_36440# 0.0704f
C53 m1_68300_3080# vdd_ext 0.24419f
C54 reset latch_sense_p_ext 0.19529f
C55 sar_readout_12b_0.vdd row_drive 0.58157f
C56 m4_45060_36440# vdd_ext 0.01404f
C57 iso_tail_ext vdd_ext 0.86179f
C58 row_dac_10b_0.vdd row_drive 1.11462f
C59 physical_preamp_n.sar_comparator_input row_drive 0.71865f
C60 latch_sense_n_ext m4_32000_38940# 0.0096f
C61 decision_n decision_p 2.54301f
C62 iso_tail_ext sar_comparator_input 0.16721f
C63 m4_45060_36440# latch_sense_p_ext 0.00796f
C64 iso_tail_ext latch_sense_p_ext 0.1295f
C65 decision_p vdd_ext 3.8282f
C66 decision_n latch_sense_n_ext 0.37635f
C67 vss row_drive 0.22445f
C68 eval vdd_ext 0
C69 tail_ext decision_p 0.48065f
C70 tail_ext eval 0.36751f
C71 m2_42000_41940# row_drive 0.12051f
C72 latch_sense_n_ext vdd_ext 4.55721f
C73 vss shared_converter_mux_0.mux_bus 0.03132f
C74 tail_ext latch_sense_n_ext 1.09601f
C75 vss vss_escape 36.2394f
C76 vdd vss_escape 36.7f
C77 iso_tail_ext vss_escape 84.72649f
C78 decision_p vss_escape 13.12464f
C79 tail_ext vss_escape 0.1277p
C80 latch_sense_n_ext vss_escape 9.0153f
C81 latch_sense_p_ext vss_escape 54.743f
C82 vdd_ext vss_escape 0.25979p
C83 m4_51060_36440# vss_escape 0.12744f ; **FLOATING
C84 m4_45060_36440# vss_escape 0.09034f ; **FLOATING
C85 m4_32000_38940# vss_escape 0.1568f ; **FLOATING
C86 m2_42000_41940# vss_escape 3.91591f ; **FLOATING
C87 sar_readout_12b_0.vss vss_escape 1.33686f ; **FLOATING
C88 row_dac_10b_0.vss vss_escape 1.40333f ; **FLOATING
C89 row_dac_10b_0.vdd vss_escape 1.33457f ; **FLOATING
C90 sar_readout_12b_0.vdd vss_escape 1.77614f ; **FLOATING
C91 m1_68300_3080# vss_escape 7.89552f ; **FLOATING
C92 shared_converter_mux_0.vss vss_escape 1.39454f ; **FLOATING
C93 shared_converter_mux_0.mux_bus vss_escape 2.86922f ; **FLOATING
C94 shared_converter_mux_0.vdd vss_escape 0.95985f ; **FLOATING
.ends
