* NGSPICE file created from aimc_converter_macro_active_candidate.ext - technology: sky130A

.subckt sky130_transistor_active_isolation_pair iso_tail iso_p iso_n sense_p sense_n
+ m1_3440_500# m1_1000_500# m2_900_1400# VSUBS
X0 iso_tail sense_n iso_n VSUBS sky130_fd_pr__nfet_01v8 ad=3.12 pd=7.6 as=3.36 ps=8 w=1.2 l=0.6
X1 iso_p sense_p iso_tail VSUBS sky130_fd_pr__nfet_01v8 ad=3.36 pd=8 as=3.12 ps=7.6 w=1.2 l=0.6
C0 m1_1000_500# sense_p 0.04555f
C1 m2_900_1400# sense_p 0.04273f
C2 m2_900_1400# m1_1000_500# 0.01113f
C3 m1_3440_500# iso_n 0.0015f
C4 iso_tail iso_p 0.05749f
C5 sense_n iso_tail 0.11179f
C6 sense_p iso_p 0.02157f
C7 m1_1000_500# iso_p 0.0015f
C8 m2_900_1400# iso_p 0.41846f
C9 sense_n m2_900_1400# 0.04273f
C10 m1_3440_500# iso_tail 0.0015f
C11 iso_tail iso_n 0.05717f
C12 m1_3440_500# m2_900_1400# 0.01113f
C13 m2_900_1400# iso_n 0.41846f
C14 iso_n iso_p 0.00782f
C15 iso_tail sense_p 0.12292f
C16 m1_3440_500# sense_n 0.04555f
C17 sense_n iso_n 0.02157f
C18 iso_tail m1_1000_500# 0.0015f
C19 iso_tail m2_900_1400# 0.34398f
C20 iso_n VSUBS 1.04634f
C21 iso_p VSUBS 1.04634f
C22 iso_tail VSUBS 4.24257f
C23 m2_900_1400# VSUBS 1.01648f
C24 m1_3440_500# VSUBS 0.31893f
C25 m1_1000_500# VSUBS 0.31893f
.ends

.subckt escaped_input_latch out_p out_n latch_sense_p latch_sense_n tail reset vdd
+ vss eval sense_p sense_n iso_tail vdd_active
X0 out_p out_n vdd_active vdd_active sky130_fd_pr__pfet_01v8 ad=3.36 pd=8 as=3.12 ps=7.6 w=1.2 l=0.6
X1 vdd reset out_n vdd sky130_fd_pr__pfet_01v8 ad=3.12 pd=7.6 as=3.36 ps=8 w=1.2 l=0.6
X2 tail out_p out_n vss sky130_fd_pr__nfet_01v8 ad=3.12 pd=7.6 as=3.36 ps=8 w=1.2 l=0.6
X3 out_p reset vdd vdd sky130_fd_pr__pfet_01v8 ad=3.36 pd=8 as=3.12 ps=7.6 w=1.2 l=0.6
X4 out_p out_n tail vss sky130_fd_pr__nfet_01v8 ad=3.36 pd=8 as=3.12 ps=7.6 w=1.2 l=0.6
X5 tail latch_sense_n out_n vss sky130_fd_pr__nfet_01v8 ad=3.12 pd=7.6 as=3.36 ps=8 w=1.2 l=0.6
X6 tail eval vss vss sky130_fd_pr__nfet_01v8 ad=16.2 pd=17.4 as=16.2 ps=17.4 w=6 l=0.6
X7 out_p latch_sense_p tail vss sky130_fd_pr__nfet_01v8 ad=3.36 pd=8 as=3.12 ps=7.6 w=1.2 l=0.6
X8 iso_tail sense_n latch_sense_n vss sky130_fd_pr__nfet_01v8 ad=3.12 pd=7.6 as=3.36 ps=8 w=1.2 l=0.6
X9 vdd_active out_p out_n vdd_active sky130_fd_pr__pfet_01v8 ad=3.12 pd=7.6 as=3.36 ps=8 w=1.2 l=0.6
X10 latch_sense_p sense_p iso_tail vss sky130_fd_pr__nfet_01v8 ad=3.36 pd=8 as=3.12 ps=7.6 w=1.2 l=0.6
C0 out_n vdd_active 3.16716f
C1 latch_sense_p iso_tail 0.20888f
C2 vdd out_n 0.77104f
C3 sense_n iso_tail 0.10725f
C4 tail reset 0.16491f
C5 latch_sense_p tail 0.0334f
C6 eval tail 0.35666f
C7 out_n reset 0.31048f
C8 iso_tail sense_p 0.26105f
C9 vdd reset 4.47121f
C10 iso_tail latch_sense_n 0.20888f
C11 tail latch_sense_n 0.0334f
C12 tail out_p 0.46979f
C13 out_p vdd_active 3.06556f
C14 out_n latch_sense_n 0.18428f
C15 out_n out_p 2.54301f
C16 vdd out_p 0.76206f
C17 latch_sense_p sense_p 0.22977f
C18 out_p reset 0.376f
C19 tail vdd_active 0.9938f
C20 latch_sense_p out_p 0.18428f
C21 sense_n latch_sense_n 0.22977f
C22 tail out_n 0.46979f
C23 tail vdd 0.9918f
C24 iso_tail vss 29.23796f
C25 latch_sense_n vss 1.7693f
C26 latch_sense_p vss 1.56796f
C27 out_n vss 13.58747f
C28 tail vss 89.03816f
C29 vdd_active vss 90.11912f
C30 vdd vss 78.65506f
.ends

.subckt aimc_converter_macro_active_candidate vss vdd row_drive sar_comparator_input
+ decision_p decision_n reset eval vss_escape latch_sense_p_ext latch_sense_n_ext
+ iso_tail_ext tail_ext vdd_ext
Xphysical_preamp_0 physical_preamp_0/iso_tail physical_preamp_0/iso_p physical_preamp_0/iso_n
+ physical_preamp_0/sense_p physical_preamp_0/sense_n sar_comparator_input row_drive
+ physical_preamp_0/m2_900_1400# vss_escape sky130_transistor_active_isolation_pair
Xconverter_latch_0 decision_p decision_n latch_sense_p_ext latch_sense_n_ext tail_ext
+ reset vdd_ext vss_escape eval row_drive sar_comparator_input iso_tail_ext vdd_ext
+ escaped_input_latch
C0 sar_readout_12b_0/vdd iso_tail_ext 0.27521f
C1 shared_converter_mux_0/vdd row_drive 0.00246f
C2 row_dac_10b_0/vdd row_drive 1.11462f
C3 row_drive latch_sense_n_ext 0.21988f
C4 row_drive physical_preamp_0/m2_900_1400# -0.00731f
C5 m1_65540_3540# vss 0.00394f
C6 vdd_ext sar_readout_12b_0/vss 0.93663f
C7 shared_converter_mux_0/mux_bus vdd_ext 0.00217f
C8 shared_converter_mux_0/mux_bus vss 0.03132f
C9 sar_readout_12b_0/vdd vdd_ext 1.39936f
C10 eval vdd_ext 0
C11 sar_comparator_input physical_preamp_0/sense_n 0.02993f
C12 m1_67140_3540# vss 0.00304f
C13 row_drive sar_readout_12b_0/vss 0.29422f
C14 shared_converter_mux_0/mux_bus row_drive 0.06281f
C15 physical_preamp_0/iso_tail sar_comparator_input 0.0361f
C16 sar_readout_12b_0/vdd row_drive 0.57218f
C17 latch_sense_p_ext vss 0.23329f
C18 shared_converter_mux_0/mux_bus shared_converter_mux_0/vdd 1.55306f
C19 vdd_ext decision_p 0
C20 vdd_ext shared_converter_mux_0/vss 0
C21 vdd row_drive 0.1964f
C22 physical_preamp_0/iso_tail row_drive 0.02329f
C23 vdd_ext reset 0.01669f
C24 vdd_ext iso_tail_ext 0.3078f
C25 physical_preamp_0/sense_n physical_preamp_0/m2_900_1400# -0.00318f
C26 latch_sense_p_ext row_drive 0.2194f
C27 sar_comparator_input physical_preamp_0/iso_n 0.027f
C28 sar_comparator_input iso_tail_ext 0.05996f
C29 eval tail_ext 0.01085f
C30 decision_n tail_ext 0.01085f
C31 row_drive shared_converter_mux_0/vss 0.00246f
C32 m1_67140_3540# m4_67140_4340# 0.00867f
C33 sar_readout_12b_0/vdd sar_readout_12b_0/vss 0.49712f
C34 vdd_ext vss 0.19458f
C35 row_drive iso_tail_ext 1.71857f
C36 sar_comparator_input vdd_ext 0.06859f
C37 physical_preamp_0/iso_p sar_comparator_input 0.02717f
C38 physical_preamp_0/sense_p sar_comparator_input 0.04049f
C39 m1_65540_3540# m1_67140_3540# 0.01006f
C40 physical_preamp_0/iso_tail m1_65540_3540# 0.00394f
C41 tail_ext decision_p 0.01085f
C42 physical_preamp_0/iso_n physical_preamp_0/m2_900_1400# -0
C43 tail_ext reset 0.01085f
C44 vdd_ext row_drive 2.1538f
C45 vss row_drive 0.22445f
C46 physical_preamp_0/iso_p row_drive -0
C47 physical_preamp_0/sense_p row_drive 0.03836f
C48 sar_comparator_input row_drive 5.23145f
C49 vdd_ext shared_converter_mux_0/vdd 0
C50 shared_converter_mux_0/vdd vss 0.2816f
C51 row_dac_10b_0/vss row_drive 1.08123f
C52 shared_converter_mux_0/mux_bus shared_converter_mux_0/vss 1.56188f
C53 physical_preamp_0/iso_tail m1_67140_3540# 0.00394f
C54 vss latch_sense_n_ext 0.23329f
C55 physical_preamp_0/iso_p physical_preamp_0/m2_900_1400# 0
C56 m4_67140_4340# vss 0.00363f
C57 physical_preamp_0/sense_p physical_preamp_0/m2_900_1400# -0.00637f
C58 iso_tail_ext sar_readout_12b_0/vss 0.60045f
C59 sar_comparator_input latch_sense_n_ext -0
C60 sar_comparator_input physical_preamp_0/m2_900_1400# 0.16477f
C61 row_dac_10b_0/vss row_dac_10b_0/vdd 0.78467f
C62 m3_69940_2940# m1_69940_2940# 0.03103f
C63 vss vss_escape 36.6898f
C64 vdd vss_escape 36.7f
C65 m4_67140_4340# vss_escape 0.07466f ; **FLOATING
C66 m3_69940_2940# vss_escape 0.18641f ; **FLOATING
C67 m1_69940_2940# vss_escape 0.19727f ; **FLOATING
C68 m1_67140_3540# vss_escape 0.32849f ; **FLOATING
C69 m1_65540_3540# vss_escape 0.34229f ; **FLOATING
C70 iso_tail_ext vss_escape -1.05232f
C71 sar_comparator_input vss_escape 10.66696f
C72 latch_sense_n_ext vss_escape -0.27849f
C73 latch_sense_p_ext vss_escape -0.37707f
C74 decision_n vss_escape 3.8093f
C75 eval vss_escape 0.78348f
C76 row_drive vss_escape 19.1176f
C77 vdd_ext vss_escape 34.08534f
.ends
