* NGSPICE file created from aimc_converter_macro_active_candidate.ext - technology: sky130A

.subckt sky130_isolated_frontend_active_load_latch_v2 out_p out_n latch_sense_p latch_sense_n
+ tail reset vdd vss eval sense_p sense_n iso_tail vdd_active
X0 latch_sense_p sense_p iso_tail vss sky130_fd_pr__nfet_01v8 ad=3.36 pd=8 as=3.12 ps=7.6 w=1.2 l=0.6
X1 out_p out_n tail vss sky130_fd_pr__nfet_01v8 ad=3.36 pd=8 as=3.12 ps=7.6 w=1.2 l=0.6
X2 out_n latch_sense_n tail vss sky130_fd_pr__nfet_01v8 ad=3.36 pd=8 as=3.12 ps=7.6 w=1.2 l=0.6
X3 out_n out_p vdd_active vdd_active sky130_fd_pr__pfet_01v8 ad=3.36 pd=8 as=3.12 ps=7.6 w=1.2 l=0.6
X4 iso_tail sense_n latch_sense_n vss sky130_fd_pr__nfet_01v8 ad=3.12 pd=7.6 as=3.36 ps=8 w=1.2 l=0.6
X5 out_n out_p tail vss sky130_fd_pr__nfet_01v8 ad=3.36 pd=8 as=3.12 ps=7.6 w=1.2 l=0.6
X6 out_n reset vdd vdd sky130_fd_pr__pfet_01v8 ad=3.36 pd=8 as=3.12 ps=7.6 w=1.2 l=0.6
X7 out_p latch_sense_p tail vss sky130_fd_pr__nfet_01v8 ad=3.36 pd=8 as=3.12 ps=7.6 w=1.2 l=0.6
X8 tail eval vss vss sky130_fd_pr__nfet_01v8 ad=16.8 pd=17.6 as=15.6 ps=17.2 w=6 l=0.6
X9 out_p out_n vdd_active vdd_active sky130_fd_pr__pfet_01v8 ad=3.36 pd=8 as=3.12 ps=7.6 w=1.2 l=0.6
X10 out_p reset vdd vdd sky130_fd_pr__pfet_01v8 ad=3.36 pd=8 as=3.12 ps=7.6 w=1.2 l=0.6
C0 latch_sense_n iso_tail 0.15122f
C1 latch_sense_n latch_sense_p 0.0207f
C2 out_p vdd_active 4.31746f
C3 latch_sense_p iso_tail 0.09804f
C4 out_n reset 0.05967f
C5 latch_sense_n out_n 1.04924f
C6 latch_sense_n sense_n 0.05507f
C7 sense_n iso_tail 0.11179f
C8 iso_tail sense_p 0.12292f
C9 out_n latch_sense_p 0.27084f
C10 latch_sense_p sense_p 0.06485f
C11 out_p reset 0.07615f
C12 out_p latch_sense_n 1.00043f
C13 eval out_n 0.02298f
C14 out_p latch_sense_p 0.32159f
C15 iso_tail m1_1000_12500# 0.00302f
C16 out_p out_n 1.85382f
C17 latch_sense_p m1_1000_12500# 0.05106f
C18 out_p eval 0.04062f
C19 sense_p m1_1000_12500# 0.04904f
C20 tail latch_sense_n 0.4349f
C21 tail latch_sense_p 0.36163f
C22 tail out_n 2.28538f
C23 reset vdd 4.28849f
C24 tail eval 0.09415f
C25 tail out_p 3.33055f
C26 latch_sense_n m1_3440_12500# 0.0106f
C27 out_n vdd 0.95698f
C28 iso_tail m1_3440_12500# 0.00302f
C29 latch_sense_n vdd_active 0.53393f
C30 latch_sense_p vdd_active 0.50449f
C31 sense_n m1_3440_12500# 0.04904f
C32 out_n vdd_active 5.52673f
C33 out_p vdd 1.0487f
C34 tail vss 27.29601f
C35 out_p vss 12.23545f
C36 latch_sense_n vss 0.71261f
C37 iso_tail vss 4.24257f
C38 vdd vss 31.12f
C39 vdd_active vss 65.63497f
C40 m1_3440_12500# vss 0.33861f ; **FLOATING
C41 m1_1000_12500# vss 0.33861f ; **FLOATING
.ends

.subckt aimc_converter_macro_active_candidate vss vdd row_drive column_sense digital_code_out
Xconverter_latch_0 converter_latch_0/out_p converter_latch_0/out_n row_drive converter_latch_0/latch_sense_n
+ vss converter_latch_0/reset converter_latch_0/vdd vss converter_latch_0/eval converter_latch_0/sense_p
+ converter_latch_0/sense_n converter_latch_0/iso_tail converter_latch_0/vdd_active
+ sky130_isolated_frontend_active_load_latch_v2
C0 sar_readout_12b_0/sample_in sar_readout_12b_0/vss 1.05402f
C1 row_drive row_dac_10b_0/vdd 1.11409f
C2 row_dac_10b_0/vss row_drive 1.08123f
C3 shared_converter_mux_0/vdd shared_converter_mux_0/mux_bus 1.55306f
C4 vdd row_drive 0.1964f
C5 sar_readout_12b_0/sample_in row_drive 0.73243f
C6 shared_converter_mux_0/vdd row_drive 0.00246f
C7 sar_readout_12b_0/vss row_drive 0.23863f
C8 converter_latch_0/eval converter_latch_0/out_n -0.00131f
C9 shared_converter_mux_0/mux_bus row_drive 0.06281f
C10 vdd column_sense 0.1964f
C11 shared_converter_mux_0/vss shared_converter_mux_0/mux_bus 1.56188f
C12 column_sense sar_readout_12b_0/sample_in 0
C13 column_sense sar_readout_12b_0/vss 0
C14 shared_converter_mux_0/vss row_drive 0.00246f
C15 sar_readout_12b_0/vdd sar_readout_12b_0/sample_in 1.3202f
C16 sar_readout_12b_0/vdd sar_readout_12b_0/vss 0.53484f
C17 row_dac_10b_0/vss row_dac_10b_0/vdd 0.78467f
C18 converter_latch_0/eval converter_latch_0/out_p -0.00523f
C19 column_sense row_drive 0.15628f
C20 sar_readout_12b_0/vdd row_drive 0.33264f
C21 digital_code_out vdd 0.1964f
C22 sar_readout_12b_0/vdd column_sense 0.03336f
C23 digital_code_out vss 22.16245f
C24 column_sense vss 22.16245f
C25 vdd vss 22.6565f
C26 converter_latch_0/eval vss 0.05552f
C27 converter_latch_0/out_p vss 1.36292f
C28 converter_latch_0/out_n vss 0.6673f
C29 converter_latch_0/latch_sense_n vss 0.05384f
C30 row_drive vss 21.39173f
C31 shared_converter_mux_0/mux_bus vss 0.03132f
C32 shared_converter_mux_0/vdd vss 0.2816f
.ends
