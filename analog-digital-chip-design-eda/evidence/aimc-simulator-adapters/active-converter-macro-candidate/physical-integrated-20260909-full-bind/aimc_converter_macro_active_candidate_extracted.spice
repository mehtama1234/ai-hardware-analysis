* NGSPICE file created from aimc_converter_macro_active_candidate_flat.ext - technology: sky130A

.subckt aimc_converter_macro_active_candidate_flat vss vdd row_drive sar_comparator_input
+ decision_p decision_n reset eval vss_escape latch_sense_p_ext latch_sense_n_ext
+ iso_tail_ext tail_ext vdd_ext
X0 vdd_ext physical_preamp_0.sense_n vdd_ext vss_escape sky130_fd_pr__nfet_01v8 ad=3.36 pd=8 as=15.36 ps=44 w=1.2 l=0.6
X1 vdd_ext decision_p decision_n vdd_ext sky130_fd_pr__pfet_01v8 ad=3.12 pd=7.6 as=3.36 ps=8 w=1.2 l=0.6
X2 tail_ext eval vss_escape vss_escape sky130_fd_pr__nfet_01v8 ad=16.2 pd=17.4 as=16.2 ps=17.4 w=6 l=0.6
X3 vdd_ext physical_preamp_0.sense_p vdd_ext vss_escape sky130_fd_pr__nfet_01v8 ad=3.12 pd=7.6 as=0 ps=0 w=1.2 l=0.6
X4 decision_p latch_sense_p_ext tail_ext vss_escape sky130_fd_pr__nfet_01v8 ad=3.36 pd=8 as=3.12 ps=7.6 w=1.2 l=0.6
X5 vdd_ext reset decision_n vdd_ext sky130_fd_pr__pfet_01v8 ad=3.12 pd=7.6 as=3.36 ps=8 w=1.2 l=0.6
X6 tail_ext latch_sense_n_ext decision_n vss_escape sky130_fd_pr__nfet_01v8 ad=3.12 pd=7.6 as=3.36 ps=8 w=1.2 l=0.6
X7 decision_p decision_n vdd_ext vdd_ext sky130_fd_pr__pfet_01v8 ad=3.36 pd=8 as=3.12 ps=7.6 w=1.2 l=0.6
X8 tail_ext decision_p decision_n vss_escape sky130_fd_pr__nfet_01v8 ad=3.12 pd=7.6 as=3.36 ps=8 w=1.2 l=0.6
X9 latch_sense_p_ext row_drive iso_tail_ext vss_escape sky130_fd_pr__nfet_01v8 ad=3.36 pd=8 as=3.12 ps=7.6 w=1.2 l=0.6
X10 iso_tail_ext sar_comparator_input latch_sense_n_ext vss_escape sky130_fd_pr__nfet_01v8 ad=3.12 pd=7.6 as=3.36 ps=8 w=1.2 l=0.6
X11 decision_p reset vdd_ext vdd_ext sky130_fd_pr__pfet_01v8 ad=3.36 pd=8 as=3.12 ps=7.6 w=1.2 l=0.6
X12 decision_p decision_n tail_ext vss_escape sky130_fd_pr__nfet_01v8 ad=3.36 pd=8 as=3.12 ps=7.6 w=1.2 l=0.6
C0 latch_sense_n_ext iso_tail_ext 0.12577f
C1 sar_readout_12b_0.vdd sar_readout_12b_0.vss 0.49712f
C2 vdd_ext latch_sense_n_ext 3.48444f
C3 latch_sense_p_ext tail_ext 0.0334f
C4 row_drive iso_tail_ext 1.97962f
C5 row_drive vdd_ext 2.72443f
C6 vdd_ext decision_p 3.8282f
C7 row_drive latch_sense_p_ext 0.24412f
C8 latch_sense_p_ext decision_p 0.18428f
C9 vdd_ext eval 0
C10 physical_preamp_0.sense_p sar_comparator_input 0.04049f
C11 shared_converter_mux_0.vdd vss 0.2816f
C12 row_drive row_dac_10b_0.vdd 1.11462f
C13 reset tail_ext 0.17577f
C14 latch_sense_n_ext vss 0.23329f
C15 row_dac_10b_0.vss row_drive 1.08123f
C16 row_drive m2_64900_1400# 0.00382f
C17 row_drive vss 0.22445f
C18 shared_converter_mux_0.vdd shared_converter_mux_0.mux_bus 1.55306f
C19 sar_readout_12b_0.vdd iso_tail_ext 0.27521f
C20 sar_readout_12b_0.vss iso_tail_ext 0.60045f
C21 vdd_ext sar_readout_12b_0.vdd 1.39936f
C22 vdd_ext sar_readout_12b_0.vss 0.93663f
C23 reset decision_p 0.376f
C24 row_drive shared_converter_mux_0.mux_bus 0.06281f
C25 physical_preamp_0.sense_p vdd_ext 0.19915f
C26 row_drive shared_converter_mux_0.vss 0.00246f
C27 sar_comparator_input iso_tail_ext 0.16721f
C28 vdd_ext sar_comparator_input 1.15159f
C29 physical_preamp_0.sense_n sar_comparator_input 0.07548f
C30 tail_ext decision_n 0.48065f
C31 latch_sense_n_ext decision_n 0.18428f
C32 vdd_ext iso_tail_ext 0.86179f
C33 physical_preamp_0.sense_p m2_64900_1400# 0.03637f
C34 decision_p decision_n 2.54301f
C35 m2_64900_1400# sar_comparator_input 0.1759f
C36 physical_preamp_0.sense_n vdd_ext 0.1567f
C37 latch_sense_p_ext iso_tail_ext 0.12577f
C38 vdd_ext latch_sense_p_ext 3.43095f
C39 vdd_ext m2_64900_1400# 1.28989f
C40 vdd_ext vss 0.20794f
C41 physical_preamp_0.sense_n m2_64900_1400# 0.03955f
C42 vdd_ext reset 4.48789f
C43 latch_sense_p_ext vss 0.23329f
C44 vdd_ext shared_converter_mux_0.mux_bus 0.00217f
C45 latch_sense_n_ext tail_ext 0.0334f
C46 row_drive shared_converter_mux_0.vdd 0.00246f
C47 vdd_ext shared_converter_mux_0.vss 0
C48 row_dac_10b_0.vss row_dac_10b_0.vdd 0.78467f
C49 tail_ext decision_p 0.48065f
C50 row_drive latch_sense_n_ext 0.20099f
C51 tail_ext eval 0.36751f
C52 shared_converter_mux_0.mux_bus vss 0.03132f
C53 vdd_ext decision_n 3.9382f
C54 row_drive vdd 0.1964f
C55 shared_converter_mux_0.mux_bus shared_converter_mux_0.vss 1.56188f
C56 row_drive sar_readout_12b_0.vdd 0.57218f
C57 row_drive sar_readout_12b_0.vss 0.29422f
C58 physical_preamp_0.sense_p row_drive 0.08156f
C59 latch_sense_n_ext sar_comparator_input 0.04279f
C60 row_drive sar_comparator_input 5.23145f
C61 reset decision_n 0.31048f
C62 vdd_ext shared_converter_mux_0.vdd 0
C63 vdd_ext tail_ext 1.9856f
C64 vss vss_escape 36.2292f
C65 vdd vss_escape 36.7f
C66 iso_tail_ext vss_escape 55.4747f
C67 latch_sense_n_ext vss_escape 8.91095f
C68 latch_sense_p_ext vss_escape 24.51545f
C69 decision_p vss_escape 7.45999f
C70 tail_ext vss_escape 81.67176f
C71 vdd_ext vss_escape 0.26925p
C72 m2_64900_1400# vss_escape 0.6909f ; **FLOATING
C73 sar_readout_12b_0.vss vss_escape 1.33686f ; **FLOATING
C74 row_dac_10b_0.vss vss_escape 1.40333f ; **FLOATING
C75 row_dac_10b_0.vdd vss_escape 1.33457f ; **FLOATING
C76 sar_readout_12b_0.vdd vss_escape 1.77614f ; **FLOATING
C77 shared_converter_mux_0.vss vss_escape 1.39454f ; **FLOATING
C78 shared_converter_mux_0.mux_bus vss_escape 2.86922f ; **FLOATING
C79 shared_converter_mux_0.vdd vss_escape 0.95985f ; **FLOATING
.ends
