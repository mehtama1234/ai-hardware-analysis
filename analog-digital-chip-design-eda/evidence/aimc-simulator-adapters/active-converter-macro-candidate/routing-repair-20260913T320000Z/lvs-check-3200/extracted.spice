* NGSPICE file created from aimc_converter_macro_active_candidate_flat.ext - technology: sky130A

.subckt aimc_converter_macro_active_candidate_flat vss vdd row_drive decision_p decision_n
+ reset eval vss_escape latch_sense_p_ext latch_sense_n_ext iso_tail_ext tail_ext
+ vdd_ext
X0 physical_preamp_0.preamp_iso_tail_ext vdd_ext physical_preamp_0.latch_sense_n_ext vss_escape sky130_fd_pr__nfet_01v8 ad=3.12 pd=7.6 as=3.36 ps=8 w=1.2 l=0.6
X1 vdd_ext decision_p decision_n vdd_ext sky130_fd_pr__pfet_01v8 ad=3.12 pd=7.6 as=3.36 ps=8 w=1.2 l=0.6
X2 tail_ext eval vss_escape vss_escape sky130_fd_pr__nfet_01v8 ad=16.2 pd=17.4 as=16.2 ps=17.4 w=6 l=0.6
X3 physical_preamp_0.latch_sense_p_ext row_drive physical_preamp_0.preamp_iso_tail_ext vss_escape sky130_fd_pr__nfet_01v8 ad=3.36 pd=8 as=3.12 ps=7.6 w=1.2 l=0.6
X4 decision_p latch_sense_p_ext tail_ext vss_escape sky130_fd_pr__nfet_01v8 ad=3.36 pd=8 as=3.12 ps=7.6 w=1.2 l=0.6
X5 vdd_ext reset decision_n vdd_ext sky130_fd_pr__pfet_01v8 ad=3.12 pd=7.6 as=3.36 ps=8 w=1.2 l=0.6
X6 tail_ext latch_sense_n_ext decision_n vss_escape sky130_fd_pr__nfet_01v8 ad=3.12 pd=7.6 as=3.36 ps=8 w=1.2 l=0.6
X7 decision_p decision_n vdd_ext vdd_ext sky130_fd_pr__pfet_01v8 ad=3.36 pd=8 as=3.12 ps=7.6 w=1.2 l=0.6
X8 tail_ext decision_p decision_n vss_escape sky130_fd_pr__nfet_01v8 ad=3.12 pd=7.6 as=3.36 ps=8 w=1.2 l=0.6
X9 latch_sense_p_ext row_drive iso_tail_ext vss_escape sky130_fd_pr__nfet_01v8 ad=3.36 pd=8 as=3.12 ps=7.6 w=1.2 l=0.6
X10 iso_tail_ext vdd_ext latch_sense_n_ext vss_escape sky130_fd_pr__nfet_01v8 ad=3.12 pd=7.6 as=3.36 ps=8 w=1.2 l=0.6
X11 decision_p reset vdd_ext vdd_ext sky130_fd_pr__pfet_01v8 ad=3.36 pd=8 as=3.12 ps=7.6 w=1.2 l=0.6
X12 decision_p decision_n tail_ext vss_escape sky130_fd_pr__nfet_01v8 ad=3.36 pd=8 as=3.12 ps=7.6 w=1.2 l=0.6
C0 sar_readout_12b_0.vss iso_tail_ext 0.60045f
C1 shared_converter_mux_0.mux_bus vss 0.03132f
C2 physical_preamp_0.preamp_iso_tail_ext physical_preamp_0.latch_sense_n_ext 0.07947f
C3 physical_preamp_0.preamp_iso_tail_ext m2_64900_1400# 0.34398f
C4 decision_p latch_sense_p_ext 0.18428f
C5 vss row_drive 0.22445f
C6 vdd_ext latch_sense_p_ext 3.43095f
C7 decision_n latch_sense_n_ext 0.18428f
C8 reset tail_ext 0.17577f
C9 iso_tail_ext latch_sense_n_ext 0.12577f
C10 physical_preamp_0.preamp_iso_tail_ext vdd_ext 0.36433f
C11 decision_p tail_ext 0.48065f
C12 vdd row_drive 0.1964f
C13 tail_ext vdd_ext 1.9856f
C14 shared_converter_mux_0.vdd vss 0.2816f
C15 physical_preamp_0.latch_sense_n_ext row_drive 0.00854f
C16 m2_64900_1400# row_drive 0.0495f
C17 physical_preamp_0.preamp_iso_tail_ext physical_preamp_0.latch_sense_p_ext 0.07124f
C18 shared_converter_mux_0.mux_bus vdd_ext 0.00217f
C19 shared_converter_mux_0.vss vdd_ext 0
C20 sar_readout_12b_0.vdd vdd_ext 1.39936f
C21 vdd_ext row_drive 11.7901f
C22 tail_ext latch_sense_n_ext 0.0334f
C23 physical_preamp_0.preamp_iso_tail_ext m1_68300_3080# 0.01748f
C24 sar_readout_12b_0.vdd sar_readout_12b_0.vss 0.49712f
C25 sar_readout_12b_0.vss row_drive 0.29433f
C26 shared_converter_mux_0.vdd vdd_ext 0
C27 physical_preamp_0.latch_sense_p_ext row_drive 0.03926f
C28 iso_tail_ext latch_sense_p_ext 0.12577f
C29 decision_n tail_ext 0.48065f
C30 row_drive latch_sense_n_ext 0.57746f
C31 m1_68300_3080# row_drive 2.68356f
C32 row_dac_10b_0.vss row_dac_10b_0.vdd 0.78467f
C33 vdd_ext eval 0
C34 sar_readout_12b_0.vdd iso_tail_ext 0.27521f
C35 iso_tail_ext row_drive 2.39704f
C36 tail_ext latch_sense_p_ext 0.0334f
C37 row_dac_10b_0.vdd row_drive 1.11462f
C38 row_drive latch_sense_p_ext 0.6214f
C39 row_dac_10b_0.vss row_drive 1.08123f
C40 vdd_ext vss 0.19458f
C41 physical_preamp_0.preamp_iso_tail_ext row_drive 0.35829f
C42 m2_64900_1400# physical_preamp_0.latch_sense_n_ext 0.43369f
C43 physical_preamp_0.latch_sense_n_ext vdd_ext 0.10121f
C44 shared_converter_mux_0.vss shared_converter_mux_0.mux_bus 1.56188f
C45 m2_64900_1400# vdd_ext 0.33293f
C46 shared_converter_mux_0.mux_bus row_drive 0.06281f
C47 decision_p reset 0.376f
C48 reset vdd_ext 4.48789f
C49 vss latch_sense_n_ext 0.23329f
C50 shared_converter_mux_0.vss row_drive 0.00246f
C51 decision_p vdd_ext 3.8282f
C52 sar_readout_12b_0.vdd row_drive 0.58157f
C53 physical_preamp_0.latch_sense_p_ext physical_preamp_0.latch_sense_n_ext 0.01253f
C54 shared_converter_mux_0.mux_bus shared_converter_mux_0.vdd 1.55306f
C55 physical_preamp_0.latch_sense_p_ext m2_64900_1400# 0.43236f
C56 shared_converter_mux_0.vdd row_drive 0.00246f
C57 sar_readout_12b_0.vss vdd_ext 0.93663f
C58 physical_preamp_0.latch_sense_p_ext vdd_ext 0.08295f
C59 tail_ext eval 0.36751f
C60 m1_68300_3080# physical_preamp_0.latch_sense_n_ext 0
C61 m1_68300_3080# m2_64900_1400# 0
C62 vdd_ext latch_sense_n_ext 3.52723f
C63 m1_68300_3080# vdd_ext 0.24447f
C64 reset decision_n 0.31048f
C65 vss latch_sense_p_ext 0.23329f
C66 decision_p decision_n 2.54301f
C67 decision_n vdd_ext 3.9382f
C68 vdd_ext iso_tail_ext 1.029f
C69 physical_preamp_0.latch_sense_p_ext m1_68300_3080# 0
C70 vss vss_escape 36.2292f
C71 vdd vss_escape 36.7f
C72 iso_tail_ext vss_escape 42.16421f
C73 latch_sense_n_ext vss_escape 21.19601f
C74 decision_p vss_escape 7.38983f
C75 tail_ext vss_escape 81.08725f
C76 m2_64900_1400# vss_escape 0.71263f ; **FLOATING
C77 sar_readout_12b_0.vss vss_escape 1.33686f ; **FLOATING
C78 row_dac_10b_0.vss vss_escape 1.40333f ; **FLOATING
C79 row_dac_10b_0.vdd vss_escape 1.33457f ; **FLOATING
C80 sar_readout_12b_0.vdd vss_escape 1.77614f ; **FLOATING
C81 m1_68300_3080# vss_escape 7.90194f ; **FLOATING
C82 shared_converter_mux_0.vss vss_escape 1.39454f ; **FLOATING
C83 shared_converter_mux_0.mux_bus vss_escape 2.86922f ; **FLOATING
C84 shared_converter_mux_0.vdd vss_escape 0.95985f ; **FLOATING
C85 physical_preamp_0.latch_sense_n_ext vss_escape 0.11961p
C86 physical_preamp_0.latch_sense_p_ext vss_escape 37.28456f
C87 physical_preamp_0.preamp_iso_tail_ext vss_escape 0.15868p
.ends
