* NGSPICE file created from preamp_port_candidate.ext - technology: sky130A

.subckt preamp_port_candidate preamp_iso_tail_ext latch_sense_p_ext latch_sense_n_ext
+ row_drive sar_comparator_input vss_escape
X0 preamp_iso_tail_ext sar_comparator_input latch_sense_n_ext vss_escape sky130_fd_pr__nfet_01v8 ad=3.12 pd=7.6 as=3.36 ps=8 w=1.2 l=0.6
X1 latch_sense_p_ext row_drive preamp_iso_tail_ext vss_escape sky130_fd_pr__nfet_01v8 ad=3.36 pd=8 as=3.12 ps=7.6 w=1.2 l=0.6
.ends
