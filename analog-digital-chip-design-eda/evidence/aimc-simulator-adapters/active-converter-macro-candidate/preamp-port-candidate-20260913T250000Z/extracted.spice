* NGSPICE file created from preamp_port_candidate.ext - technology: sky130A

.subckt preamp_port_candidate preamp_iso_tail_ext latch_sense_p_ext latch_sense_n_ext
+ row_drive sar_comparator_input vss_escape
X0 preamp_iso_tail_ext sar_comparator_input latch_sense_n_ext vss_escape sky130_fd_pr__nfet_01v8 ad=3.12 pd=7.6 as=3.36 ps=8 w=1.2 l=0.6
X1 latch_sense_p_ext row_drive preamp_iso_tail_ext vss_escape sky130_fd_pr__nfet_01v8 ad=3.36 pd=8 as=3.12 ps=7.6 w=1.2 l=0.6
C0 latch_sense_p_ext preamp_iso_tail_ext 0.05749f
C1 row_drive preamp_iso_tail_ext 0.12292f
C2 preamp_iso_tail_ext sar_comparator_input 0.11179f
C3 latch_sense_n_ext preamp_iso_tail_ext 0.05717f
C4 m1_3440_500# preamp_iso_tail_ext 0.0015f
C5 m1_1000_500# preamp_iso_tail_ext 0.0015f
C6 row_drive latch_sense_p_ext 0.02157f
C7 m2_900_1400# preamp_iso_tail_ext 0.34398f
C8 latch_sense_n_ext latch_sense_p_ext 0.00782f
C9 latch_sense_n_ext sar_comparator_input 0.02157f
C10 m1_1000_500# latch_sense_p_ext 0.0015f
C11 row_drive m1_1000_500# 0.04555f
C12 m2_900_1400# latch_sense_p_ext 0.41846f
C13 m1_3440_500# sar_comparator_input 0.04555f
C14 latch_sense_n_ext m1_3440_500# 0.0015f
C15 row_drive m2_900_1400# 0.04273f
C16 m2_900_1400# sar_comparator_input 0.04273f
C17 latch_sense_n_ext m2_900_1400# 0.41846f
C18 m2_900_1400# m1_3440_500# 0.01113f
C19 m2_900_1400# m1_1000_500# 0.01113f
C20 latch_sense_n_ext vss_escape 1.04634f
C21 latch_sense_p_ext vss_escape 1.04634f
C22 preamp_iso_tail_ext vss_escape 4.23383f
C23 m2_900_1400# vss_escape 1.01648f ; **FLOATING
C24 m1_3440_500# vss_escape 0.31893f ; **FLOATING
C25 m1_1000_500# vss_escape 0.31893f ; **FLOATING
.ends
