* NGSPICE file created from aimc_converter_macro_active_candidate.ext - technology: sky130A

.subckt sky130_transistor_active_isolation_pair iso_tail iso_p iso_n sense_p sense_n
+ m1_3440_500# m1_1000_500# m2_900_1400# VSUBS
X0 iso_tail sense_n iso_n VSUBS sky130_fd_pr__nfet_01v8 ad=3.12 pd=7.6 as=3.36 ps=8 w=1.2 l=0.6
X1 iso_p sense_p iso_tail VSUBS sky130_fd_pr__nfet_01v8 ad=3.36 pd=8 as=3.12 ps=7.6 w=1.2 l=0.6
C0 sense_n m2_900_1400# 0.04273f
C1 m1_3440_500# iso_n 0.0015f
C2 iso_p iso_n 0.00782f
C3 m1_1000_500# iso_tail 0.0015f
C4 m1_3440_500# iso_tail 0.0015f
C5 iso_p iso_tail 0.05749f
C6 m2_900_1400# m1_1000_500# 0.01113f
C7 m1_3440_500# m2_900_1400# 0.01113f
C8 iso_p m2_900_1400# 0.41846f
C9 m1_3440_500# sense_n 0.04555f
C10 sense_p iso_tail 0.12292f
C11 iso_p m1_1000_500# 0.0015f
C12 sense_p m2_900_1400# 0.04273f
C13 sense_p m1_1000_500# 0.04555f
C14 iso_n iso_tail 0.05717f
C15 sense_p iso_p 0.02157f
C16 iso_n m2_900_1400# 0.41846f
C17 iso_n sense_n 0.02157f
C18 m2_900_1400# iso_tail 0.34398f
C19 sense_n iso_tail 0.11179f
C20 iso_n VSUBS 1.04634f
C21 iso_p VSUBS 1.04634f
C22 iso_tail VSUBS 4.24257f
C23 m2_900_1400# VSUBS 1.01648f
C24 m1_3440_500# VSUBS 0.31893f
C25 m1_1000_500# VSUBS 0.31893f
.ends

.subckt escaped_input_latch out_p out_n latch_sense_p latch_sense_n tail reset vdd
+ vss eval sense_p sense_n iso_tail vdd_active
X0 out_p out_n vdd_active vdd_active sky130_fd_pr__pfet_01v8 ad=3.36 pd=8 as=3.12 ps=7.6 w=1.2 l=0.6
X1 vdd reset out_n vdd sky130_fd_pr__pfet_01v8 ad=3.12 pd=7.6 as=3.36 ps=8 w=1.2 l=0.6
X2 tail out_p out_n vss sky130_fd_pr__nfet_01v8 ad=3.12 pd=7.6 as=3.36 ps=8 w=1.2 l=0.6
X3 out_p reset vdd vdd sky130_fd_pr__pfet_01v8 ad=3.36 pd=8 as=3.12 ps=7.6 w=1.2 l=0.6
X4 out_p out_n tail vss sky130_fd_pr__nfet_01v8 ad=3.36 pd=8 as=3.12 ps=7.6 w=1.2 l=0.6
X5 tail latch_sense_n out_n vss sky130_fd_pr__nfet_01v8 ad=3.12 pd=7.6 as=3.36 ps=8 w=1.2 l=0.6
X6 tail eval vss vss sky130_fd_pr__nfet_01v8 ad=16.2 pd=17.4 as=16.2 ps=17.4 w=6 l=0.6
X7 out_p latch_sense_p tail vss sky130_fd_pr__nfet_01v8 ad=3.36 pd=8 as=3.12 ps=7.6 w=1.2 l=0.6
X8 iso_tail sense_n latch_sense_n vss sky130_fd_pr__nfet_01v8 ad=3.12 pd=7.6 as=3.36 ps=8 w=1.2 l=0.6
X9 vdd_active out_p out_n vdd_active sky130_fd_pr__pfet_01v8 ad=3.12 pd=7.6 as=3.36 ps=8 w=1.2 l=0.6
X10 latch_sense_p sense_p iso_tail vss sky130_fd_pr__nfet_01v8 ad=3.36 pd=8 as=3.12 ps=7.6 w=1.2 l=0.6
C0 sense_n iso_tail 0.10725f
C1 sense_p iso_tail 0.26105f
C2 out_p out_n 2.54301f
C3 reset out_p 0.376f
C4 out_p latch_sense_p 0.18428f
C5 out_n tail 0.46979f
C6 tail latch_sense_n 0.0334f
C7 reset tail 0.16491f
C8 vdd out_n 0.77104f
C9 latch_sense_p tail 0.0334f
C10 reset vdd 4.47121f
C11 vdd_active out_p 3.06556f
C12 out_n latch_sense_n 0.18428f
C13 vdd_active tail 0.9938f
C14 reset out_n 0.31048f
C15 iso_tail latch_sense_n 0.20888f
C16 vdd_active out_n 3.16716f
C17 latch_sense_p iso_tail 0.20888f
C18 sense_n latch_sense_n 0.22977f
C19 out_p tail 0.46979f
C20 sense_p latch_sense_p 0.22977f
C21 out_p vdd 0.76206f
C22 vdd tail 0.9918f
C23 eval tail 0.35666f
C24 iso_tail vss 29.23796f
C25 latch_sense_n vss 1.7693f
C26 latch_sense_p vss 1.56796f
C27 out_n vss 13.58747f
C28 tail vss 89.03816f
C29 vdd_active vss 90.11912f
C30 vdd vss 78.65506f
.ends

.subckt aimc_converter_macro_active_candidate vss vdd row_drive sar_comparator_input
+ decision_p decision_n reset eval vss_escape latch_sense_p_ext iso_tail_ext tail_ext
+ vdd_ext preamp_iso_tail_ext
Xphysical_preamp_0 physical_preamp_0/iso_tail physical_preamp_0/iso_p physical_preamp_0/iso_n
+ physical_preamp_0/sense_p physical_preamp_0/sense_n sar_comparator_input row_drive
+ physical_preamp_0/m2_900_1400# vss_escape sky130_transistor_active_isolation_pair
Xconverter_latch_0 decision_p decision_n latch_sense_p_ext latch_sense_p_ext tail_ext
+ reset vdd_ext vss_escape eval row_drive sar_comparator_input iso_tail_ext vdd_ext
+ escaped_input_latch
C0 row_drive physical_preamp_0/m2_900_1400# -0.00731f
C1 row_drive vdd_ext 2.1538f
C2 row_drive sar_comparator_input 5.23145f
C3 sar_readout_12b_0/vdd vdd_ext 1.39936f
C4 row_dac_10b_0/vss row_dac_10b_0/vdd 0.78467f
C5 latch_sense_p_ext vdd_ext 0.33498f
C6 physical_preamp_0/m2_900_1400# physical_preamp_0/sense_n -0.00318f
C7 sar_comparator_input latch_sense_p_ext 0.00226f
C8 sar_comparator_input physical_preamp_0/sense_n 0.02993f
C9 row_drive sar_readout_12b_0/vdd 0.57218f
C10 row_drive latch_sense_p_ext 0.44552f
C11 vss m1_67140_3540# 0.00304f
C12 physical_preamp_0/m2_900_1400# physical_preamp_0/sense_p -0.00637f
C13 physical_preamp_0/sense_p sar_comparator_input 0.04049f
C14 physical_preamp_0/m2_900_1400# physical_preamp_0/iso_p 0
C15 physical_preamp_0/iso_p sar_comparator_input 0.02717f
C16 row_drive physical_preamp_0/sense_p 0.03836f
C17 row_drive physical_preamp_0/iso_p -0
C18 sar_readout_12b_0/vss iso_tail_ext 0.60045f
C19 physical_preamp_0/sense_p latch_sense_p_ext 0.00135f
C20 m1_67140_3540# latch_sense_p_ext 0.02746f
C21 shared_converter_mux_0/vdd shared_converter_mux_0/mux_bus 1.55306f
C22 iso_tail_ext vdd_ext 0.3078f
C23 row_drive row_dac_10b_0/vdd 1.11462f
C24 sar_comparator_input iso_tail_ext 0.05996f
C25 shared_converter_mux_0/mux_bus shared_converter_mux_0/vss 1.56188f
C26 sar_comparator_input physical_preamp_0/iso_tail 0.0361f
C27 row_drive row_dac_10b_0/vss 1.08123f
C28 row_drive iso_tail_ext 1.71857f
C29 iso_tail_ext sar_readout_12b_0/vdd 0.27521f
C30 row_drive physical_preamp_0/iso_tail 0.02329f
C31 vss shared_converter_mux_0/vdd 0.2816f
C32 iso_tail_ext latch_sense_p_ext 0.00637f
C33 latch_sense_p_ext physical_preamp_0/iso_tail 0.01386f
C34 decision_n tail_ext 0.01085f
C35 shared_converter_mux_0/vdd vdd_ext 0
C36 vss shared_converter_mux_0/mux_bus 0.03132f
C37 preamp_iso_tail_ext m1_69940_2940# 0.03103f
C38 vdd_ext shared_converter_mux_0/vss 0
C39 row_drive shared_converter_mux_0/vdd 0.00246f
C40 sar_readout_12b_0/vss vdd_ext 0.93663f
C41 row_drive vdd 0.1964f
C42 shared_converter_mux_0/mux_bus vdd_ext 0.00217f
C43 row_drive shared_converter_mux_0/vss 0.00246f
C44 row_drive sar_readout_12b_0/vss 0.29422f
C45 sar_readout_12b_0/vss sar_readout_12b_0/vdd 0.49712f
C46 physical_preamp_0/m2_900_1400# physical_preamp_0/iso_n -0
C47 reset vdd_ext 0.01669f
C48 decision_p vdd_ext 0
C49 sar_comparator_input physical_preamp_0/iso_n 0.027f
C50 row_drive shared_converter_mux_0/mux_bus 0.06281f
C51 eval vdd_ext 0
C52 vss vdd_ext 0.19458f
C53 reset tail_ext 0.01085f
C54 decision_p tail_ext 0.01085f
C55 m1_67140_3540# physical_preamp_0/iso_tail 0.00394f
C56 eval tail_ext 0.01085f
C57 row_drive vss 0.22445f
C58 physical_preamp_0/m2_900_1400# sar_comparator_input 0.16477f
C59 sar_comparator_input vdd_ext 0.06859f
C60 vss latch_sense_p_ext 1.61192f
C61 preamp_iso_tail_ext vss_escape 0.18641f
C62 vss vss_escape 36.6898f
C63 vdd vss_escape 36.7f
C64 m1_69940_2940# vss_escape 0.19727f ; **FLOATING
C65 m1_67140_3540# vss_escape 0.32849f ; **FLOATING
C66 iso_tail_ext vss_escape -1.05232f
C67 sar_comparator_input vss_escape 10.66696f
C68 latch_sense_p_ext vss_escape 13.2832f
C69 decision_n vss_escape 3.8093f
C70 eval vss_escape 0.78348f
C71 row_drive vss_escape 19.1176f
C72 vdd_ext vss_escape 34.08534f
.ends
