* NGSPICE file created from aimc_converter_macro_active_candidate.ext - technology: sky130A

.subckt sky130_transistor_active_isolation_pair iso_tail iso_p iso_n sense_p sense_n
+ m1_3440_500# m1_1000_500# m2_900_1400# VSUBS
X0 iso_tail sense_n iso_n VSUBS sky130_fd_pr__nfet_01v8 ad=3.12 pd=7.6 as=3.36 ps=8 w=1.2 l=0.6
X1 iso_p sense_p iso_tail VSUBS sky130_fd_pr__nfet_01v8 ad=3.36 pd=8 as=3.12 ps=7.6 w=1.2 l=0.6
C0 m2_900_1400# m1_3440_500# 0.01113f
C1 m2_900_1400# m1_1000_500# 0.01113f
C2 sense_p iso_p 0.02157f
C3 sense_p iso_tail 0.12292f
C4 m1_3440_500# iso_n 0.0015f
C5 iso_tail m1_3440_500# 0.0015f
C6 m2_900_1400# sense_n 0.04273f
C7 m1_1000_500# iso_p 0.0015f
C8 m1_1000_500# iso_tail 0.0015f
C9 iso_n sense_n 0.02157f
C10 m2_900_1400# iso_n 0.41846f
C11 iso_tail sense_n 0.11179f
C12 m2_900_1400# iso_p 0.41846f
C13 m2_900_1400# iso_tail 0.34398f
C14 sense_p m1_1000_500# 0.04555f
C15 iso_p iso_n 0.00782f
C16 iso_tail iso_n 0.05717f
C17 iso_tail iso_p 0.05749f
C18 m2_900_1400# sense_p 0.04273f
C19 m1_3440_500# sense_n 0.04555f
C20 iso_n VSUBS 1.04634f
C21 iso_p VSUBS 1.04634f
C22 iso_tail VSUBS 4.24257f
C23 m2_900_1400# VSUBS 1.01648f
C24 m1_3440_500# VSUBS 0.31893f
C25 m1_1000_500# VSUBS 0.31893f
.ends

.subckt escaped_input_latch out_p out_n latch_sense_p latch_sense_n tail reset vdd
+ vss eval sense_p sense_n iso_tail vdd_active
X0 out_p out_n vdd_active vdd_active sky130_fd_pr__pfet_01v8 ad=3.36 pd=8 as=3.12 ps=7.6 w=1.2 l=0.6
X1 vdd reset out_n vdd sky130_fd_pr__pfet_01v8 ad=3.12 pd=7.6 as=3.36 ps=8 w=1.2 l=0.6
X2 tail out_p out_n vss sky130_fd_pr__nfet_01v8 ad=3.12 pd=7.6 as=3.36 ps=8 w=1.2 l=0.6
X3 out_p reset vdd vdd sky130_fd_pr__pfet_01v8 ad=3.36 pd=8 as=3.12 ps=7.6 w=1.2 l=0.6
X4 out_p out_n tail vss sky130_fd_pr__nfet_01v8 ad=3.36 pd=8 as=3.12 ps=7.6 w=1.2 l=0.6
X5 tail latch_sense_n out_n vss sky130_fd_pr__nfet_01v8 ad=3.12 pd=7.6 as=3.36 ps=8 w=1.2 l=0.6
X6 tail eval vss vss sky130_fd_pr__nfet_01v8 ad=16.2 pd=17.4 as=16.2 ps=17.4 w=6 l=0.6
X7 out_p latch_sense_p tail vss sky130_fd_pr__nfet_01v8 ad=3.36 pd=8 as=3.12 ps=7.6 w=1.2 l=0.6
X8 iso_tail sense_n latch_sense_n vss sky130_fd_pr__nfet_01v8 ad=3.12 pd=7.6 as=3.36 ps=8 w=1.2 l=0.6
X9 vdd_active out_p out_n vdd_active sky130_fd_pr__pfet_01v8 ad=3.12 pd=7.6 as=3.36 ps=8 w=1.2 l=0.6
X10 latch_sense_p sense_p iso_tail vss sky130_fd_pr__nfet_01v8 ad=3.36 pd=8 as=3.12 ps=7.6 w=1.2 l=0.6
C0 sense_n iso_tail 0.10725f
C1 latch_sense_p iso_tail 0.20888f
C2 latch_sense_p sense_p 0.22977f
C3 vdd out_n 0.77104f
C4 vdd_active out_p 3.06556f
C5 latch_sense_n out_n 0.18428f
C6 vdd_active tail 0.9938f
C7 out_n out_p 2.54301f
C8 iso_tail sense_p 0.26105f
C9 out_n reset 0.31048f
C10 out_n tail 0.46979f
C11 vdd out_p 0.76206f
C12 sense_n latch_sense_n 0.22977f
C13 tail eval 0.35666f
C14 vdd reset 4.47121f
C15 vdd tail 0.9918f
C16 latch_sense_n tail 0.0334f
C17 vdd_active out_n 3.16716f
C18 latch_sense_p out_p 0.18428f
C19 reset out_p 0.376f
C20 tail out_p 0.46979f
C21 iso_tail latch_sense_n 0.20888f
C22 latch_sense_p tail 0.0334f
C23 tail reset 0.16491f
C24 iso_tail vss 29.23796f
C25 latch_sense_n vss 1.7693f
C26 latch_sense_p vss 1.56796f
C27 out_n vss 13.58747f
C28 tail vss 89.03816f
C29 vdd_active vss 90.11912f
C30 vdd vss 78.65506f
.ends

.subckt aimc_converter_macro_active_candidate vss vdd row_drive sar_comparator_input
+ decision_p decision_n reset eval vss_escape vdd_ext iso_tail_ext tail_ext
Xphysical_preamp_0 physical_preamp_0/iso_tail physical_preamp_0/iso_p physical_preamp_0/iso_n
+ physical_preamp_0/sense_p physical_preamp_0/sense_n sar_comparator_input row_drive
+ vdd_ext vss_escape sky130_transistor_active_isolation_pair
Xconverter_latch_0 decision_p decision_n vdd_ext vdd_ext tail_ext reset vdd_ext vss_escape
+ eval row_drive sar_comparator_input iso_tail_ext vdd_ext escaped_input_latch
C0 sar_readout_12b_0/vdd vdd_ext 1.39936f
C1 vdd_ext reset 0.01669f
C2 vdd_ext eval 0
C3 shared_converter_mux_0/mux_bus vdd_ext 0.00217f
C4 vdd_ext physical_preamp_0/iso_p 0.11532f
C5 vdd_ext sar_readout_12b_0/vss 0.93663f
C6 vdd_ext row_drive 2.79225f
C7 physical_preamp_0/sense_p row_drive 0.0365f
C8 tail_ext decision_n 0.01085f
C9 vdd_ext physical_preamp_0/sense_n 0.02101f
C10 tail_ext decision_p 0.01085f
C11 physical_preamp_0/sense_p vdd_ext 0.04463f
C12 sar_comparator_input physical_preamp_0/iso_n 0.027f
C13 shared_converter_mux_0/mux_bus shared_converter_mux_0/vdd 1.55306f
C14 sar_comparator_input physical_preamp_0/iso_tail 0.03267f
C15 shared_converter_mux_0/vdd row_drive 0.00246f
C16 shared_converter_mux_0/mux_bus vss 0.03132f
C17 vss row_drive 0.22445f
C18 sar_comparator_input iso_tail_ext 0.05996f
C19 vdd row_drive 0.1964f
C20 sar_comparator_input physical_preamp_0/iso_p 0.02717f
C21 sar_comparator_input row_drive 5.23145f
C22 row_drive row_dac_10b_0/vdd 1.11462f
C23 vdd_ext shared_converter_mux_0/vdd 0
C24 vdd_ext decision_p 0
C25 tail_ext reset 0.01085f
C26 row_dac_10b_0/vss row_dac_10b_0/vdd 0.78467f
C27 vdd_ext vss 0.66116f
C28 shared_converter_mux_0/mux_bus shared_converter_mux_0/vss 1.56188f
C29 shared_converter_mux_0/vss row_drive 0.00246f
C30 sar_comparator_input physical_preamp_0/sense_n 0.02993f
C31 tail_ext eval 0.01085f
C32 sar_readout_12b_0/vdd iso_tail_ext 0.27521f
C33 physical_preamp_0/iso_tail row_drive 0.01828f
C34 iso_tail_ext sar_readout_12b_0/vss 0.60045f
C35 iso_tail_ext row_drive 1.71857f
C36 sar_comparator_input vdd_ext 0.98947f
C37 sar_readout_12b_0/vdd sar_readout_12b_0/vss 0.49712f
C38 physical_preamp_0/sense_p sar_comparator_input 0.04049f
C39 sar_readout_12b_0/vdd row_drive 0.57218f
C40 vdd_ext shared_converter_mux_0/vss 0
C41 shared_converter_mux_0/mux_bus row_drive 0.06281f
C42 physical_preamp_0/iso_p row_drive -0
C43 row_drive sar_readout_12b_0/vss 0.29422f
C44 vdd_ext physical_preamp_0/iso_n 0.07524f
C45 vdd_ext physical_preamp_0/iso_tail 0.604f
C46 vss shared_converter_mux_0/vdd 0.2816f
C47 row_drive row_dac_10b_0/vss 1.08123f
C48 iso_tail_ext vdd_ext 0.48802f
C49 vss vss_escape 36.7f
C50 vdd vss_escape 36.7f
C51 iso_tail_ext vss_escape -1.05232f
C52 sar_comparator_input vss_escape 10.29193f
C53 decision_n vss_escape 3.8093f
C54 eval vss_escape 0.78348f
C55 row_drive vss_escape 19.0962f
C56 vdd_ext vss_escape 44.36776f
.ends
