* NGSPICE file created from aimc_converter_macro_active_candidate_flat.ext - technology: sky130A

.subckt aimc_converter_macro_active_candidate_flat vss vdd row_drive decision_p decision_n
+ reset eval vss_escape latch_sense_p_ext latch_sense_n_ext iso_tail_ext tail_ext
+ vdd_ext
X0 physical_preamp_0.iso_tail physical_preamp_0.sense_n physical_preamp_0.iso_n vss_escape sky130_fd_pr__nfet_01v8 ad=3.12 pd=7.6 as=3.36 ps=8 w=1.2 l=0.6
X1 vdd_ext decision_p decision_n vdd_ext sky130_fd_pr__pfet_01v8 ad=3.12 pd=7.6 as=3.36 ps=8 w=1.2 l=0.6
X2 tail_ext eval vss_escape vss_escape sky130_fd_pr__nfet_01v8 ad=16.2 pd=17.4 as=16.2 ps=17.4 w=6 l=0.6
X3 physical_preamp_0.iso_p physical_preamp_0.sense_p physical_preamp_0.iso_tail vss_escape sky130_fd_pr__nfet_01v8 ad=3.36 pd=8 as=3.12 ps=7.6 w=1.2 l=0.6
X4 decision_p latch_sense_p_ext tail_ext vss_escape sky130_fd_pr__nfet_01v8 ad=3.36 pd=8 as=3.12 ps=7.6 w=1.2 l=0.6
X5 vdd_ext reset decision_n vdd_ext sky130_fd_pr__pfet_01v8 ad=3.12 pd=7.6 as=3.36 ps=8 w=1.2 l=0.6
X6 tail_ext latch_sense_n_ext decision_n vss_escape sky130_fd_pr__nfet_01v8 ad=3.12 pd=7.6 as=3.36 ps=8 w=1.2 l=0.6
X7 decision_p decision_n vdd_ext vdd_ext sky130_fd_pr__pfet_01v8 ad=3.36 pd=8 as=3.12 ps=7.6 w=1.2 l=0.6
X8 tail_ext decision_p decision_n vss_escape sky130_fd_pr__nfet_01v8 ad=3.12 pd=7.6 as=3.36 ps=8 w=1.2 l=0.6
X9 latch_sense_p_ext row_drive iso_tail_ext vss_escape sky130_fd_pr__nfet_01v8 ad=3.36 pd=8 as=3.12 ps=7.6 w=1.2 l=0.6
X10 iso_tail_ext row_drive latch_sense_n_ext vss_escape sky130_fd_pr__nfet_01v8 ad=3.12 pd=7.6 as=3.36 ps=8 w=1.2 l=0.6
X11 decision_p reset vdd_ext vdd_ext sky130_fd_pr__pfet_01v8 ad=3.36 pd=8 as=3.12 ps=7.6 w=1.2 l=0.6
X12 decision_p decision_n tail_ext vss_escape sky130_fd_pr__nfet_01v8 ad=3.36 pd=8 as=3.12 ps=7.6 w=1.2 l=0.6
C0 vdd_ext m3_42000_3080# 0.66292f
C1 latch_sense_p_ext decision_p 0.18428f
C2 latch_sense_n_ext iso_tail_ext 0.12577f
C3 shared_converter_mux_0.mux_bus vss 0.03132f
C4 latch_sense_p_ext iso_tail_ext 0.12577f
C5 physical_preamp_0.sense_p m3_42000_3080# 0.00502f
C6 row_dac_10b_0.vss row_dac_10b_0.vdd 0.78467f
C7 reset tail_ext 0.17577f
C8 vdd_ext shared_converter_mux_0.vdd 0
C9 vdd_ext decision_p 3.8282f
C10 shared_converter_mux_0.mux_bus row_drive 0.06281f
C11 physical_preamp_0.iso_tail physical_preamp_0.iso_p 0.05749f
C12 shared_converter_mux_0.vss row_drive 0.00246f
C13 physical_preamp_0.iso_tail physical_preamp_0.iso_n 0.05717f
C14 vdd_ext iso_tail_ext 0.86179f
C15 sar_readout_12b_0.vss iso_tail_ext 0.60045f
C16 m3_42000_3080# li_67560_2680# 0.05138f
C17 vdd_ext physical_preamp_0.iso_p 0.02484f
C18 vdd_ext physical_preamp_0.iso_n 0.0106f
C19 eval tail_ext 0.36751f
C20 shared_converter_mux_0.vdd vss 0.2816f
C21 decision_n tail_ext 0.48065f
C22 physical_preamp_0.sense_n physical_preamp_0.iso_tail 0.12768f
C23 sar_readout_12b_0.vdd iso_tail_ext 0.27521f
C24 decision_p reset 0.376f
C25 physical_preamp_0.sense_n vdd_ext 0.00836f
C26 physical_preamp_0.sense_p physical_preamp_0.iso_p 0.02157f
C27 physical_preamp_0.iso_tail m2_64900_1400# 0.34398f
C28 shared_converter_mux_0.vdd row_drive 0.00246f
C29 row_dac_10b_0.vss row_drive 1.08123f
C30 row_drive iso_tail_ext 2.14683f
C31 vdd_ext m2_64900_1400# 0.07254f
C32 shared_converter_mux_0.vss shared_converter_mux_0.mux_bus 1.56188f
C33 physical_preamp_0.iso_p row_drive 0.04554f
C34 physical_preamp_0.iso_n row_drive 0.04554f
C35 decision_n decision_p 2.54301f
C36 physical_preamp_0.sense_p m2_64900_1400# 0.03637f
C37 physical_preamp_0.sense_n row_drive 0.10005f
C38 physical_preamp_0.sense_n li_67560_2680# 0.10828f
C39 vdd_ext latch_sense_n_ext 3.48444f
C40 shared_converter_mux_0.mux_bus shared_converter_mux_0.vdd 1.55306f
C41 decision_p tail_ext 0.48065f
C42 row_drive m2_64900_1400# 0.18484f
C43 li_67560_2680# m2_64900_1400# 0.00235f
C44 vdd_ext latch_sense_p_ext 3.43095f
C45 vdd_ext physical_preamp_0.iso_tail 0.30194f
C46 vss latch_sense_n_ext 0.23329f
C47 m3_42000_3080# physical_preamp_0.iso_p 0.00159f
C48 m3_42000_3080# physical_preamp_0.iso_n 0.00159f
C49 vss latch_sense_p_ext 0.23329f
C50 row_drive vdd 0.1964f
C51 vdd_ext sar_readout_12b_0.vss 0.93663f
C52 row_drive latch_sense_n_ext 0.24379f
C53 physical_preamp_0.sense_p physical_preamp_0.iso_tail 0.12279f
C54 physical_preamp_0.sense_n m3_42000_3080# 0.00955f
C55 row_drive latch_sense_p_ext 0.24412f
C56 vdd_ext sar_readout_12b_0.vdd 1.39936f
C57 vdd_ext physical_preamp_0.sense_p 0.03258f
C58 vdd_ext vss 0.21361f
C59 sar_readout_12b_0.vdd sar_readout_12b_0.vss 0.49712f
C60 latch_sense_n_ext decision_n 0.18428f
C61 physical_preamp_0.iso_tail row_drive 0.101f
C62 row_dac_10b_0.vdd row_drive 1.11462f
C63 li_67560_2680# physical_preamp_0.iso_tail 0.18744f
C64 m3_42000_3080# m2_64900_1400# 0.00202f
C65 vdd_ext reset 4.48789f
C66 physical_preamp_0.iso_p physical_preamp_0.iso_n 0.00782f
C67 vdd_ext row_drive 3.76938f
C68 vdd_ext li_67560_2680# 0.02014f
C69 row_drive sar_readout_12b_0.vss 0.29422f
C70 latch_sense_n_ext tail_ext 0.0334f
C71 vdd_ext eval 0
C72 sar_readout_12b_0.vdd row_drive 0.57218f
C73 physical_preamp_0.sense_n physical_preamp_0.iso_n 0.02157f
C74 vdd_ext decision_n 3.9382f
C75 physical_preamp_0.sense_p row_drive 0.18727f
C76 vss row_drive 0.22445f
C77 latch_sense_p_ext tail_ext 0.0334f
C78 physical_preamp_0.iso_p m2_64900_1400# 0.41846f
C79 physical_preamp_0.iso_n m2_64900_1400# 0.41846f
C80 li_67560_2680# row_drive 0.01882f
C81 m3_42000_3080# physical_preamp_0.iso_tail 0.06211f
C82 vdd_ext shared_converter_mux_0.mux_bus 0.00217f
C83 vdd_ext tail_ext 1.9856f
C84 vdd_ext shared_converter_mux_0.vss 0
C85 physical_preamp_0.sense_n m2_64900_1400# 0.04052f
C86 decision_n reset 0.31048f
C87 vss vss_escape 36.2211f
C88 vdd vss_escape 36.7f
C89 iso_tail_ext vss_escape 55.97575f
C90 latch_sense_p_ext vss_escape 33.92745f
C91 decision_p vss_escape 7.45999f
C92 tail_ext vss_escape 81.67176f
C93 vdd_ext vss_escape 0.25933p
C94 m3_42000_3080# vss_escape 11.7137f ; **FLOATING
C95 m2_64900_1400# vss_escape 0.71887f ; **FLOATING
C96 sar_readout_12b_0.vss vss_escape 1.33686f ; **FLOATING
C97 row_dac_10b_0.vss vss_escape 1.40333f ; **FLOATING
C98 row_dac_10b_0.vdd vss_escape 1.33457f ; **FLOATING
C99 sar_readout_12b_0.vdd vss_escape 1.77614f ; **FLOATING
C100 shared_converter_mux_0.vss vss_escape 1.39454f ; **FLOATING
C101 shared_converter_mux_0.mux_bus vss_escape 2.86922f ; **FLOATING
C102 shared_converter_mux_0.vdd vss_escape 0.95985f ; **FLOATING
C103 li_67560_2680# vss_escape 1.59527f ; **FLOATING
C104 physical_preamp_0.iso_n vss_escape 1.18745f
C105 physical_preamp_0.iso_p vss_escape 1.01323f
C106 physical_preamp_0.iso_tail vss_escape 4.05931f
.ends
