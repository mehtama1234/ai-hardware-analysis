* NGSPICE file created from aimc_converter_macro_active_candidate_flat.ext - technology: sky130A

.subckt aimc_converter_macro_active_candidate_flat vss vdd row_drive sar_comparator_input
+ decision_p reset eval vss_escape iso_tail_ext vdd_ext
X0 vdd_ext physical_preamp_n.sar_comparator_input preamp_iso_tail_ext vss_escape sky130_fd_pr__nfet_01v8 ad=3.36 pd=8 as=3.12 ps=7.6 w=1.2 l=0.6
X1 vdd_ext decision_p vdd_ext vdd_ext sky130_fd_pr__pfet_01v8 ad=3.36 pd=8 as=19.2 ps=46.4 w=1.2 l=0.6
X2 vdd_ext eval vss_escape vss_escape sky130_fd_pr__nfet_01v8 ad=16.2 pd=17.4 as=16.2 ps=17.4 w=6 l=0.6
X3 decision_p vdd_ext vdd_ext vss_escape sky130_fd_pr__nfet_01v8 ad=3.36 pd=8 as=3.12 ps=7.6 w=1.2 l=0.6
X4 vdd_ext reset vdd_ext vdd_ext sky130_fd_pr__pfet_01v8 ad=3.36 pd=8 as=0 ps=0 w=1.2 l=0.6
X5 vdd_ext vdd_ext vdd_ext vss_escape sky130_fd_pr__nfet_01v8 ad=3.36 pd=8 as=51.24 ps=108.6 w=1.2 l=0.6
X6 decision_p vdd_ext vdd_ext vdd_ext sky130_fd_pr__pfet_01v8 ad=3.36 pd=8 as=3.12 ps=7.6 w=1.2 l=0.6
X7 vdd_ext decision_p vdd_ext vss_escape sky130_fd_pr__nfet_01v8 ad=3.36 pd=8 as=0 ps=0 w=1.2 l=0.6
X8 vdd_ext row_drive iso_tail_ext vss_escape sky130_fd_pr__nfet_01v8 ad=3.36 pd=8 as=3.12 ps=7.6 w=1.2 l=0.6
X9 iso_tail_ext sar_comparator_input vdd_ext vss_escape sky130_fd_pr__nfet_01v8 ad=3.12 pd=7.6 as=3.36 ps=8 w=1.2 l=0.6
X10 vdd_ext row_drive preamp_iso_tail_ext vss_escape sky130_fd_pr__nfet_01v8 ad=3.36 pd=8 as=3.12 ps=7.6 w=1.2 l=0.6
X11 decision_p reset vdd_ext vdd_ext sky130_fd_pr__pfet_01v8 ad=3.36 pd=8 as=3.12 ps=7.6 w=1.2 l=0.6
X12 decision_p vdd_ext vdd_ext vss_escape sky130_fd_pr__nfet_01v8 ad=3.36 pd=8 as=3.12 ps=7.6 w=1.2 l=0.6
C0 sar_readout_12b_0.vss row_drive 0.29433f
C1 physical_preamp_n.sar_comparator_input row_drive 0.71865f
C2 vdd_ext reset 5.16943f
C3 decision_p reset 0.376f
C4 sar_comparator_input iso_tail_ext 0.16721f
C5 vdd_ext m4_45060_36440# 0.02766f
C6 vdd_ext vss 0.83469f
C7 vdd_ext sar_readout_12b_0.vdd 1.39936f
C8 shared_converter_mux_0.mux_bus shared_converter_mux_0.vss 1.56188f
C9 m4_45060_36440# row_drive 0.10035f
C10 vss row_drive 0.22445f
C11 physical_preamp_n.sar_comparator_input m4_45060_36440# 0.00629f
C12 sar_readout_12b_0.vdd row_drive 0.58157f
C13 sar_readout_12b_0.vss sar_readout_12b_0.vdd 0.49712f
C14 row_dac_10b_0.vdd row_drive 1.11462f
C15 vdd_ext shared_converter_mux_0.mux_bus 0.00217f
C16 row_dac_10b_0.vss row_drive 1.08123f
C17 shared_converter_mux_0.mux_bus row_drive 0.06281f
C18 vdd_ext iso_tail_ext 1.12128f
C19 preamp_iso_tail_ext m4_51060_36440# 0.00179f
C20 vdd_ext sar_comparator_input 1.11046f
C21 vdd_ext m1_68300_3080# 0.24419f
C22 vdd_ext m4_32000_38940# 0.01429f
C23 vdd_ext shared_converter_mux_0.vdd 0
C24 iso_tail_ext row_drive 2.39704f
C25 sar_readout_12b_0.vss iso_tail_ext 0.60045f
C26 row_dac_10b_0.vdd row_dac_10b_0.vss 0.78467f
C27 vdd_ext m4_51060_36440# 0.02452f
C28 sar_comparator_input row_drive 5.22878f
C29 shared_converter_mux_0.mux_bus vss 0.03132f
C30 m1_68300_3080# row_drive 2.68328f
C31 vdd_ext shared_converter_mux_0.vss 0
C32 preamp_iso_tail_ext vdd_ext 0.93726f
C33 shared_converter_mux_0.vdd row_drive 0.00246f
C34 vdd_ext eval 0.56561f
C35 physical_preamp_n.sar_comparator_input m4_51060_36440# 0.06975f
C36 m2_42000_41940# row_drive 0.12051f
C37 sar_readout_12b_0.vdd iso_tail_ext 0.27521f
C38 shared_converter_mux_0.vss row_drive 0.00246f
C39 preamp_iso_tail_ext row_drive 0.07646f
C40 physical_preamp_n.sar_comparator_input preamp_iso_tail_ext 0.09492f
C41 vdd_ext decision_p 7.2282f
C42 shared_converter_mux_0.vdd vss 0.2816f
C43 vdd row_drive 0.1964f
C44 vdd_ext row_drive 7.37603f
C45 sar_readout_12b_0.vss vdd_ext 0.93663f
C46 physical_preamp_n.sar_comparator_input vdd_ext 0.46494f
C47 preamp_iso_tail_ext m4_45060_36440# 0
C48 shared_converter_mux_0.vdd shared_converter_mux_0.mux_bus 1.55306f
C49 vss vss_escape 36.2394f
C50 vdd vss_escape 36.7f
C51 iso_tail_ext vss_escape 84.72649f
C52 decision_p vss_escape 0.13139p
C53 m4_51060_36440# vss_escape 0.1151f ; **FLOATING
C54 m4_45060_36440# vss_escape 0.09034f ; **FLOATING
C55 m4_32000_38940# vss_escape 0.15359f ; **FLOATING
C56 m2_42000_41940# vss_escape 3.91591f ; **FLOATING
C57 sar_readout_12b_0.vss vss_escape 1.33686f ; **FLOATING
C58 row_dac_10b_0.vss vss_escape 1.40333f ; **FLOATING
C59 row_dac_10b_0.vdd vss_escape 1.33457f ; **FLOATING
C60 sar_readout_12b_0.vdd vss_escape 1.77614f ; **FLOATING
C61 m1_68300_3080# vss_escape 7.89552f ; **FLOATING
C62 shared_converter_mux_0.vss vss_escape 1.39454f ; **FLOATING
C63 shared_converter_mux_0.mux_bus vss_escape 2.86922f ; **FLOATING
C64 shared_converter_mux_0.vdd vss_escape 0.95985f ; **FLOATING
C65 preamp_iso_tail_ext vss_escape 7.44563f
.ends
