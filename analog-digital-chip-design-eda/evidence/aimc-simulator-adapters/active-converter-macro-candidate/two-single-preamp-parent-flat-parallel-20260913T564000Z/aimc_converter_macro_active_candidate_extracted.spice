* NGSPICE file created from aimc_converter_macro_active_candidate_flat.ext - technology: sky130A

.subckt aimc_converter_macro_active_candidate_flat vss vdd row_drive sar_comparator_input
+ decision_p decision_n reset eval vss_escape latch_sense_p_ext latch_sense_n_ext
+ iso_tail_ext tail_ext vdd_ext
X0 vdd_ext decision_p decision_n vdd_ext sky130_fd_pr__pfet_01v8 ad=3.12 pd=7.6 as=3.36 ps=8 w=1.2 l=0.6
X1 tail_ext eval vss_escape vss_escape sky130_fd_pr__nfet_01v8 ad=16.2 pd=17.4 as=16.2 ps=17.4 w=6 l=0.6
X2 physical_preamp_n.drain physical_preamp_n.gate physical_preamp_n.source vss_escape sky130_fd_pr__nfet_01v8 ad=3.36 pd=8 as=3.12 ps=7.6 w=1.2 l=0.6
X3 decision_p latch_sense_p_ext tail_ext vss_escape sky130_fd_pr__nfet_01v8 ad=3.36 pd=8 as=3.12 ps=7.6 w=1.2 l=0.6
X4 vdd_ext reset decision_n vdd_ext sky130_fd_pr__pfet_01v8 ad=3.12 pd=7.6 as=3.36 ps=8 w=1.2 l=0.6
X5 tail_ext latch_sense_n_ext decision_n vss_escape sky130_fd_pr__nfet_01v8 ad=3.12 pd=7.6 as=3.36 ps=8 w=1.2 l=0.6
X6 decision_p decision_n vdd_ext vdd_ext sky130_fd_pr__pfet_01v8 ad=3.36 pd=8 as=3.12 ps=7.6 w=1.2 l=0.6
X7 tail_ext decision_p decision_n vss_escape sky130_fd_pr__nfet_01v8 ad=3.12 pd=7.6 as=3.36 ps=8 w=1.2 l=0.6
X8 latch_sense_p_ext row_drive iso_tail_ext vss_escape sky130_fd_pr__nfet_01v8 ad=3.36 pd=8 as=3.12 ps=7.6 w=1.2 l=0.6
X9 iso_tail_ext sar_comparator_input latch_sense_n_ext vss_escape sky130_fd_pr__nfet_01v8 ad=3.12 pd=7.6 as=3.36 ps=8 w=1.2 l=0.6
X10 decision_p reset vdd_ext vdd_ext sky130_fd_pr__pfet_01v8 ad=3.36 pd=8 as=3.12 ps=7.6 w=1.2 l=0.6
X11 physical_preamp_p.drain physical_preamp_p.gate physical_preamp_p.source vss_escape sky130_fd_pr__nfet_01v8 ad=3.36 pd=8 as=3.12 ps=7.6 w=1.2 l=0.6
X12 decision_p decision_n tail_ext vss_escape sky130_fd_pr__nfet_01v8 ad=3.36 pd=8 as=3.12 ps=7.6 w=1.2 l=0.6
C0 latch_sense_p_ext tail_ext 0.0334f
C1 row_drive latch_sense_n_ext 0.57746f
C2 sar_readout_12b_0.vss row_drive 0.29433f
C3 m1_68300_3080# vdd_ext 0.24419f
C4 row_drive vdd_ext 3.82508f
C5 row_dac_10b_0.vss row_dac_10b_0.vdd 0.78467f
C6 reset decision_n 0.31048f
C7 physical_preamp_n.drain physical_preamp_n.gate 0.02459f
C8 reset tail_ext 0.17577f
C9 decision_n latch_sense_n_ext 0.18428f
C10 vss row_drive 0.22445f
C11 latch_sense_n_ext tail_ext 0.0334f
C12 decision_n vdd_ext 3.9382f
C13 physical_preamp_n.source row_drive 0.18919f
C14 tail_ext vdd_ext 1.9856f
C15 sar_readout_12b_0.vdd row_drive 0.58157f
C16 eval vdd_ext 0
C17 physical_preamp_p.source physical_preamp_p.drain 0.05749f
C18 physical_preamp_n.gate latch_sense_n_ext 0.04639f
C19 physical_preamp_n.gate vdd_ext 0.03679f
C20 shared_converter_mux_0.vdd vdd_ext 0
C21 sar_comparator_input row_drive 5.22878f
C22 shared_converter_mux_0.mux_bus row_drive 0.06281f
C23 shared_converter_mux_0.vss vdd_ext 0
C24 iso_tail_ext latch_sense_p_ext 0.12577f
C25 physical_preamp_p.source row_drive 0.18415f
C26 physical_preamp_n.drain latch_sense_n_ext 0.46997f
C27 physical_preamp_p.gate latch_sense_p_ext 0.16164f
C28 shared_converter_mux_0.vdd vss 0.2816f
C29 physical_preamp_p.drain row_drive 0.02699f
C30 physical_preamp_n.source physical_preamp_n.gate 0.12469f
C31 physical_preamp_n.drain vdd_ext 0.01965f
C32 latch_sense_p_ext vdd_ext 3.43095f
C33 decision_n decision_p 2.54301f
C34 iso_tail_ext latch_sense_n_ext 0.12577f
C35 sar_readout_12b_0.vss iso_tail_ext 0.60045f
C36 reset vdd_ext 4.48789f
C37 tail_ext decision_p 0.48065f
C38 iso_tail_ext vdd_ext 0.86179f
C39 physical_preamp_n.source physical_preamp_n.drain 0.05749f
C40 latch_sense_p_ext vss 0.23329f
C41 row_drive m1_68300_3080# 2.68328f
C42 physical_preamp_p.gate vdd_ext 0.02484f
C43 latch_sense_n_ext vdd_ext 3.48444f
C44 sar_readout_12b_0.vss vdd_ext 0.93663f
C45 shared_converter_mux_0.mux_bus shared_converter_mux_0.vdd 1.55306f
C46 vdd row_drive 0.1964f
C47 shared_converter_mux_0.mux_bus shared_converter_mux_0.vss 1.56188f
C48 iso_tail_ext sar_readout_12b_0.vdd 0.27521f
C49 vss latch_sense_n_ext 0.23329f
C50 physical_preamp_n.source latch_sense_n_ext 0.23843f
C51 vss vdd_ext 0.19458f
C52 physical_preamp_n.source vdd_ext 0.04877f
C53 sar_readout_12b_0.vss sar_readout_12b_0.vdd 0.49712f
C54 sar_readout_12b_0.vdd vdd_ext 1.39936f
C55 latch_sense_p_ext decision_p 0.18428f
C56 sar_comparator_input iso_tail_ext 0.16721f
C57 latch_sense_p_ext physical_preamp_p.source 0.32442f
C58 physical_preamp_n.gate row_drive 0.06269f
C59 latch_sense_p_ext physical_preamp_p.drain 0.48515f
C60 shared_converter_mux_0.vdd row_drive 0.00246f
C61 decision_n tail_ext 0.48065f
C62 sar_comparator_input latch_sense_n_ext 0.04279f
C63 row_dac_10b_0.vdd row_drive 1.11462f
C64 reset decision_p 0.376f
C65 row_dac_10b_0.vss row_drive 1.08123f
C66 sar_comparator_input vdd_ext 1.06679f
C67 row_drive shared_converter_mux_0.vss 0.00246f
C68 eval tail_ext 0.36751f
C69 shared_converter_mux_0.mux_bus vdd_ext 0.00217f
C70 physical_preamp_p.gate physical_preamp_p.source 0.12469f
C71 decision_p vdd_ext 3.8282f
C72 physical_preamp_n.drain row_drive 0.02918f
C73 physical_preamp_p.gate physical_preamp_p.drain 0.02459f
C74 latch_sense_p_ext row_drive 0.6214f
C75 physical_preamp_p.source vdd_ext 0.00874f
C76 physical_preamp_p.drain vdd_ext 0.01028f
C77 shared_converter_mux_0.mux_bus vss 0.03132f
C78 iso_tail_ext row_drive 2.39704f
C79 physical_preamp_p.gate row_drive 0.053f
C80 vss vss_escape 36.2045f
C81 vdd vss_escape 36.7f
C82 iso_tail_ext vss_escape 65.87169f
C83 latch_sense_n_ext vss_escape 9.0153f
C84 latch_sense_p_ext vss_escape 35.8882f
C85 decision_p vss_escape 7.3468f
C86 tail_ext vss_escape 80.74525f
C87 vdd_ext vss_escape 0.2571p
C88 sar_readout_12b_0.vss vss_escape 1.33686f ; **FLOATING
C89 row_dac_10b_0.vss vss_escape 1.40333f ; **FLOATING
C90 row_dac_10b_0.vdd vss_escape 1.33457f ; **FLOATING
C91 sar_readout_12b_0.vdd vss_escape 1.77614f ; **FLOATING
C92 m1_68300_3080# vss_escape 7.89552f ; **FLOATING
C93 shared_converter_mux_0.vss vss_escape 1.39454f ; **FLOATING
C94 shared_converter_mux_0.mux_bus vss_escape 2.86922f ; **FLOATING
C95 shared_converter_mux_0.vdd vss_escape 0.95985f ; **FLOATING
C96 physical_preamp_n.drain vss_escape 1.34581f
C97 physical_preamp_n.source vss_escape 2.20928f
C98 physical_preamp_p.drain vss_escape 1.34581f
C99 physical_preamp_p.source vss_escape 2.20928f
.ends
