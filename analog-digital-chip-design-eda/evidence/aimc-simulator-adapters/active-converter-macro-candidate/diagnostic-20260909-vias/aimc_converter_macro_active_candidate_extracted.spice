* NGSPICE file created from aimc_converter_macro_active_candidate.ext - technology: sky130A

.subckt sky130_transistor_active_isolation_pair iso_tail iso_p iso_n sense_p sense_n
+ m1_3440_500# m1_1000_500# m2_900_1400# VSUBS
X0 iso_tail sense_n iso_n VSUBS sky130_fd_pr__nfet_01v8 ad=3.12 pd=7.6 as=3.36 ps=8 w=1.2 l=0.6
X1 iso_p sense_p iso_tail VSUBS sky130_fd_pr__nfet_01v8 ad=3.36 pd=8 as=3.12 ps=7.6 w=1.2 l=0.6
C0 m1_1000_500# sense_p 0.04555f
C1 iso_p iso_n 0.00782f
C2 iso_tail sense_n 0.11179f
C3 m1_3440_500# sense_n 0.04555f
C4 m1_1000_500# iso_p 0.0015f
C5 iso_tail sense_p 0.12292f
C6 m2_900_1400# iso_n 0.41846f
C7 iso_tail iso_p 0.05749f
C8 m1_1000_500# m2_900_1400# 0.01113f
C9 iso_p sense_p 0.02157f
C10 iso_tail m2_900_1400# 0.34398f
C11 m1_3440_500# m2_900_1400# 0.01113f
C12 iso_tail iso_n 0.05717f
C13 m1_3440_500# iso_n 0.0015f
C14 m2_900_1400# sense_n 0.04273f
C15 m1_1000_500# iso_tail 0.0015f
C16 m2_900_1400# sense_p 0.04273f
C17 iso_n sense_n 0.02157f
C18 iso_tail m1_3440_500# 0.0015f
C19 iso_p m2_900_1400# 0.41846f
C20 iso_n VSUBS 1.04634f
C21 iso_p VSUBS 1.04634f
C22 iso_tail VSUBS 4.24257f
C23 m2_900_1400# VSUBS 1.01648f
C24 m1_3440_500# VSUBS 0.31893f
C25 m1_1000_500# VSUBS 0.31893f
.ends

.subckt escaped_input_latch out_p out_n latch_sense_p latch_sense_n tail reset vdd
+ vss eval sense_p sense_n iso_tail vdd_active
X0 out_p out_n vdd_active vdd_active sky130_fd_pr__pfet_01v8 ad=3.36 pd=8 as=3.12 ps=7.6 w=1.2 l=0.6
X1 vdd reset out_n vdd sky130_fd_pr__pfet_01v8 ad=3.12 pd=7.6 as=3.36 ps=8 w=1.2 l=0.6
X2 tail out_p out_n vss sky130_fd_pr__nfet_01v8 ad=3.12 pd=7.6 as=3.36 ps=8 w=1.2 l=0.6
X3 out_p reset vdd vdd sky130_fd_pr__pfet_01v8 ad=3.36 pd=8 as=3.12 ps=7.6 w=1.2 l=0.6
X4 out_p out_n tail vss sky130_fd_pr__nfet_01v8 ad=3.36 pd=8 as=3.12 ps=7.6 w=1.2 l=0.6
X5 tail latch_sense_n out_n vss sky130_fd_pr__nfet_01v8 ad=3.12 pd=7.6 as=3.36 ps=8 w=1.2 l=0.6
X6 tail eval vss vss sky130_fd_pr__nfet_01v8 ad=16.2 pd=17.4 as=16.2 ps=17.4 w=6 l=0.6
X7 out_p latch_sense_p tail vss sky130_fd_pr__nfet_01v8 ad=3.36 pd=8 as=3.12 ps=7.6 w=1.2 l=0.6
X8 iso_tail sense_n latch_sense_n vss sky130_fd_pr__nfet_01v8 ad=3.12 pd=7.6 as=3.36 ps=8 w=1.2 l=0.6
X9 vdd_active out_p out_n vdd_active sky130_fd_pr__pfet_01v8 ad=3.12 pd=7.6 as=3.36 ps=8 w=1.2 l=0.6
X10 latch_sense_p sense_p iso_tail vss sky130_fd_pr__nfet_01v8 ad=3.36 pd=8 as=3.12 ps=7.6 w=1.2 l=0.6
C0 out_n vdd_active 3.16716f
C1 reset out_p 0.376f
C2 latch_sense_p iso_tail 0.20888f
C3 sense_n iso_tail 0.10725f
C4 tail eval 0.35666f
C5 out_n reset 0.31048f
C6 tail vdd_active 0.9938f
C7 tail latch_sense_p 0.0334f
C8 vdd out_p 0.76206f
C9 sense_p iso_tail 0.26105f
C10 tail reset 0.16491f
C11 out_n vdd 0.77104f
C12 out_n latch_sense_n 0.18428f
C13 out_n out_p 2.54301f
C14 iso_tail latch_sense_n 0.20888f
C15 tail vdd 0.9918f
C16 tail latch_sense_n 0.0334f
C17 tail out_p 0.46979f
C18 sense_p latch_sense_p 0.22977f
C19 out_n tail 0.46979f
C20 sense_n latch_sense_n 0.22977f
C21 out_p vdd_active 3.06556f
C22 out_p latch_sense_p 0.18428f
C23 reset vdd 4.47121f
C24 iso_tail vss 29.23796f
C25 latch_sense_n vss 1.7693f
C26 latch_sense_p vss 1.56796f
C27 out_n vss 13.58747f
C28 tail vss 89.03816f
C29 vdd_active vss 90.11912f
C30 vdd vss 78.65506f
.ends

.subckt aimc_converter_macro_active_candidate vss vdd row_drive sar_comparator_input
+ decision_p decision_n reset eval vss_escape latch_sense_p_ext latch_sense_n_ext
+ iso_tail_ext tail_ext vdd_ext
Xphysical_preamp_0 physical_preamp_0/iso_tail physical_preamp_0/iso_p physical_preamp_0/iso_n
+ physical_preamp_0/sense_p physical_preamp_0/sense_n sar_comparator_input m2_65120_540#
+ physical_preamp_0/m2_900_1400# vss_escape sky130_transistor_active_isolation_pair
Xconverter_latch_0 decision_p decision_n latch_sense_p_ext latch_sense_n_ext tail_ext
+ reset vdd_ext vss_escape eval row_drive sar_comparator_input iso_tail_ext vdd_ext
+ escaped_input_latch
C0 shared_converter_mux_0/vdd row_drive 0.00246f
C1 shared_converter_mux_0/vdd shared_converter_mux_0/mux_bus 1.55306f
C2 sar_comparator_input physical_preamp_0/iso_p 0.02717f
C3 physical_preamp_0/m2_900_1400# physical_preamp_0/iso_p 0
C4 sar_comparator_input physical_preamp_0/iso_tail 0.0361f
C5 physical_preamp_0/m2_900_1400# sar_comparator_input 0.16477f
C6 physical_preamp_0/sense_p m2_65120_540# 0.03361f
C7 row_drive vdd_ext 1.5596f
C8 shared_converter_mux_0/mux_bus vdd_ext 0.00217f
C9 sar_readout_12b_0/vdd vdd_ext 1.39936f
C10 physical_preamp_0/sense_p sar_comparator_input 0.04049f
C11 physical_preamp_0/m2_900_1400# physical_preamp_0/sense_p -0.00637f
C12 sar_readout_12b_0/vss vdd_ext 0.93663f
C13 decision_p tail_ext 0.01085f
C14 vdd row_drive 0.1964f
C15 vss row_drive 0.22445f
C16 vss shared_converter_mux_0/mux_bus 0.03132f
C17 iso_tail_ext vdd_ext 0.31557f
C18 row_drive row_dac_10b_0/vss 1.08123f
C19 vss latch_sense_n_ext 0.23329f
C20 vss latch_sense_p_ext 0.23329f
C21 eval tail_ext 0.01085f
C22 decision_p vdd_ext 0
C23 row_drive shared_converter_mux_0/mux_bus 0.06281f
C24 sar_readout_12b_0/vdd row_drive 0.33523f
C25 latch_sense_p_ext row_drive 0
C26 vdd_ext shared_converter_mux_0/vss 0
C27 sar_comparator_input iso_tail_ext 0.08712f
C28 sar_readout_12b_0/vss row_drive 0.21493f
C29 tail_ext decision_n 0.01085f
C30 eval vdd_ext 0
C31 sar_readout_12b_0/vss sar_readout_12b_0/vdd 0.49712f
C32 reset tail_ext 0.01085f
C33 shared_converter_mux_0/vdd vdd_ext 0
C34 iso_tail_ext row_drive 0.26323f
C35 iso_tail_ext sar_readout_12b_0/vdd 0.27625f
C36 row_dac_10b_0/vdd row_dac_10b_0/vss 0.78467f
C37 row_dac_10b_0/vdd row_drive 1.11446f
C38 row_drive shared_converter_mux_0/vss 0.00246f
C39 shared_converter_mux_0/mux_bus shared_converter_mux_0/vss 1.56188f
C40 reset vdd_ext 0.01669f
C41 iso_tail_ext sar_readout_12b_0/vss 0.60149f
C42 sar_comparator_input vdd_ext 0.07181f
C43 vss shared_converter_mux_0/vdd 0.2816f
C44 m2_65120_540# physical_preamp_0/iso_p -0
C45 sar_comparator_input physical_preamp_0/sense_n 0.02993f
C46 physical_preamp_0/m2_900_1400# physical_preamp_0/sense_n -0.00318f
C47 m2_65120_540# sar_comparator_input 0.03275f
C48 m2_65120_540# physical_preamp_0/iso_tail -0
C49 physical_preamp_0/m2_900_1400# m2_65120_540# -0.0087f
C50 sar_comparator_input physical_preamp_0/iso_n 0.027f
C51 physical_preamp_0/m2_900_1400# physical_preamp_0/iso_n -0
C52 vss vdd_ext 0.19458f
C53 m3_69940_2940# m1_69940_2940# 0.03103f
C54 vss vss_escape 36.7f
C55 vdd vss_escape 36.7f
C56 m3_69940_2940# vss_escape 0.18641f ; **FLOATING
C57 m1_69940_2940# vss_escape 0.19727f ; **FLOATING
C58 iso_tail_ext vss_escape -0.88568f
C59 sar_comparator_input vss_escape 10.77025f
C60 decision_n vss_escape 3.8093f
C61 eval vss_escape 0.78348f
C62 m2_65120_540# vss_escape 0.15443f
C63 row_drive vss_escape 7.2883f
C64 vdd_ext vss_escape 34.13324f
.ends
