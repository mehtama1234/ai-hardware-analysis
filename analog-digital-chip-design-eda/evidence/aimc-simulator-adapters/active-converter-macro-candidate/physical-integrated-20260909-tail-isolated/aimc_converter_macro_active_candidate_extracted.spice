* NGSPICE file created from aimc_converter_macro_active_candidate_flat.ext - technology: sky130A

.subckt aimc_converter_macro_active_candidate_flat vss vdd row_drive sar_comparator_input
+ decision_p decision_n reset eval vss_escape latch_sense_p_ext latch_sense_n_ext
+ iso_tail_ext tail_ext vdd_ext
X0 vdd_ext physical_preamp_0.sense_n vdd_ext vss_escape sky130_fd_pr__nfet_01v8 ad=3.36 pd=8 as=15.36 ps=44 w=1.2 l=0.6
X1 vdd_ext decision_p decision_n vdd_ext sky130_fd_pr__pfet_01v8 ad=3.12 pd=7.6 as=3.36 ps=8 w=1.2 l=0.6
X2 tail_ext eval vss_escape vss_escape sky130_fd_pr__nfet_01v8 ad=16.2 pd=17.4 as=16.2 ps=17.4 w=6 l=0.6
X3 vdd_ext physical_preamp_0.sense_p vdd_ext vss_escape sky130_fd_pr__nfet_01v8 ad=3.12 pd=7.6 as=0 ps=0 w=1.2 l=0.6
X4 decision_p latch_sense_p_ext tail_ext vss_escape sky130_fd_pr__nfet_01v8 ad=3.36 pd=8 as=3.12 ps=7.6 w=1.2 l=0.6
X5 vdd_ext reset decision_n vdd_ext sky130_fd_pr__pfet_01v8 ad=3.12 pd=7.6 as=3.36 ps=8 w=1.2 l=0.6
X6 tail_ext latch_sense_n_ext decision_n vss_escape sky130_fd_pr__nfet_01v8 ad=3.12 pd=7.6 as=3.36 ps=8 w=1.2 l=0.6
X7 decision_p decision_n vdd_ext vdd_ext sky130_fd_pr__pfet_01v8 ad=3.36 pd=8 as=3.12 ps=7.6 w=1.2 l=0.6
X8 tail_ext decision_p decision_n vss_escape sky130_fd_pr__nfet_01v8 ad=3.12 pd=7.6 as=3.36 ps=8 w=1.2 l=0.6
X9 latch_sense_p_ext row_drive iso_tail_ext vss_escape sky130_fd_pr__nfet_01v8 ad=3.36 pd=8 as=3.12 ps=7.6 w=1.2 l=0.6
X10 iso_tail_ext sar_comparator_input latch_sense_n_ext vss_escape sky130_fd_pr__nfet_01v8 ad=3.12 pd=7.6 as=3.36 ps=8 w=1.2 l=0.6
X11 decision_p reset vdd_ext vdd_ext sky130_fd_pr__pfet_01v8 ad=3.36 pd=8 as=3.12 ps=7.6 w=1.2 l=0.6
X12 decision_p decision_n tail_ext vss_escape sky130_fd_pr__nfet_01v8 ad=3.36 pd=8 as=3.12 ps=7.6 w=1.2 l=0.6
C0 vdd_ext decision_p 3.8282f
C1 row_drive latch_sense_p_ext 0.24412f
C2 latch_sense_p_ext decision_p 0.18428f
C3 vdd_ext eval 0
C4 physical_preamp_0.sense_p sar_comparator_input 0.04049f
C5 shared_converter_mux_0.vdd vss 0.2816f
C6 row_drive row_dac_10b_0.vdd 1.11462f
C7 reset tail_ext 0.17577f
C8 latch_sense_n_ext vss 0.23329f
C9 row_dac_10b_0.vss row_drive 1.08123f
C10 row_drive m2_64900_1400# 0.00382f
C11 row_drive vss 0.22445f
C12 shared_converter_mux_0.vdd shared_converter_mux_0.mux_bus 1.55306f
C13 sar_readout_12b_0.vdd iso_tail_ext 0.27521f
C14 sar_readout_12b_0.vss iso_tail_ext 0.60045f
C15 vdd_ext sar_readout_12b_0.vdd 1.39936f
C16 vdd_ext sar_readout_12b_0.vss 0.93663f
C17 reset decision_p 0.376f
C18 row_drive shared_converter_mux_0.mux_bus 0.06281f
C19 physical_preamp_0.sense_p vdd_ext 0.19881f
C20 row_drive shared_converter_mux_0.vss 0.00246f
C21 sar_comparator_input iso_tail_ext 0.16721f
C22 vdd_ext sar_comparator_input 1.15159f
C23 physical_preamp_0.sense_n sar_comparator_input 0.07548f
C24 tail_ext decision_n 0.48065f
C25 latch_sense_n_ext decision_n 0.18428f
C26 vdd_ext iso_tail_ext 0.86179f
C27 physical_preamp_0.sense_p m2_64900_1400# 0.03637f
C28 decision_p decision_n 2.54301f
C29 m2_64900_1400# sar_comparator_input 0.1759f
C30 physical_preamp_0.sense_n vdd_ext 0.15637f
C31 latch_sense_p_ext iso_tail_ext 0.12577f
C32 vdd_ext latch_sense_p_ext 3.43095f
C33 vdd_ext m2_64900_1400# 1.28748f
C34 vdd_ext vss 0.32351f
C35 physical_preamp_0.sense_n m2_64900_1400# 0.03955f
C36 vdd_ext reset 4.48789f
C37 latch_sense_p_ext vss 0.23329f
C38 vdd_ext shared_converter_mux_0.mux_bus 0.00217f
C39 latch_sense_n_ext tail_ext 0.0334f
C40 row_drive shared_converter_mux_0.vdd 0.00246f
C41 vdd_ext shared_converter_mux_0.vss 0
C42 row_dac_10b_0.vss row_dac_10b_0.vdd 0.78467f
C43 tail_ext decision_p 0.48065f
C44 row_drive latch_sense_n_ext 0.20099f
C45 tail_ext eval 0.36751f
C46 shared_converter_mux_0.mux_bus vss 0.03132f
C47 vdd_ext decision_n 3.9382f
C48 row_drive vdd 0.1964f
C49 shared_converter_mux_0.mux_bus shared_converter_mux_0.vss 1.56188f
C50 row_drive sar_readout_12b_0.vdd 0.57218f
C51 row_drive sar_readout_12b_0.vss 0.29422f
C52 physical_preamp_0.sense_p row_drive 0.08156f
C53 latch_sense_n_ext sar_comparator_input 0.04279f
C54 row_drive sar_comparator_input 5.23145f
C55 reset decision_n 0.31048f
C56 vdd_ext shared_converter_mux_0.vdd 0
C57 vdd_ext tail_ext 1.9856f
C58 latch_sense_n_ext iso_tail_ext 0.12577f
C59 sar_readout_12b_0.vdd sar_readout_12b_0.vss 0.49712f
C60 latch_sense_p_ext tail_ext 0.0334f
C61 vdd_ext latch_sense_n_ext 3.48444f
C62 row_drive iso_tail_ext 1.97962f
C63 row_drive vdd_ext 2.72443f
C64 vss vss_escape 35.9705f
C65 vdd vss_escape 36.7f
C66 iso_tail_ext vss_escape 55.4747f
C67 latch_sense_n_ext vss_escape 8.91095f
C68 latch_sense_p_ext vss_escape 24.51545f
C69 decision_p vss_escape 7.45999f
C70 tail_ext vss_escape 81.67176f
C71 vdd_ext vss_escape 0.26967p
C72 m2_64900_1400# vss_escape 0.69994f ; **FLOATING
C73 sar_readout_12b_0.vss vss_escape 1.33686f ; **FLOATING
C74 row_dac_10b_0.vss vss_escape 1.40333f ; **FLOATING
C75 row_dac_10b_0.vdd vss_escape 1.33457f ; **FLOATING
C76 sar_readout_12b_0.vdd vss_escape 1.77614f ; **FLOATING
C77 shared_converter_mux_0.vss vss_escape 1.39454f ; **FLOATING
C78 shared_converter_mux_0.mux_bus vss_escape 2.86922f ; **FLOATING
C79 shared_converter_mux_0.vdd vss_escape 0.95985f ; **FLOATING
.ends
