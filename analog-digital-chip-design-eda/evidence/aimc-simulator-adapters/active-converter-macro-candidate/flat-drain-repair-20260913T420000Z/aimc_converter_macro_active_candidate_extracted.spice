* NGSPICE file created from aimc_converter_macro_active_candidate.ext - technology: sky130A

.subckt aimc_converter_macro_active_candidate vss vdd row_drive sar_comparator_input
+ decision_p decision_n reset eval vss_escape latch_sense_p_ext latch_sense_n_ext
+ iso_tail_ext tail_ext vdd_ext
X0 physical_preamp_0.preamp_iso_tail_ext sar_comparator_input row_drive vss_escape sky130_fd_pr__nfet_01v8 ad=3.12 pd=7.6 as=3.36 ps=8 w=1.2 l=0.6
X1 vdd_ext decision_p decision_n vdd_ext sky130_fd_pr__pfet_01v8 ad=3.12 pd=7.6 as=3.36 ps=8 w=1.2 l=0.6
X2 tail_ext eval vss_escape vss_escape sky130_fd_pr__nfet_01v8 ad=16.2 pd=17.4 as=16.2 ps=17.4 w=6 l=0.6
X3 row_drive row_drive physical_preamp_0.preamp_iso_tail_ext vss_escape sky130_fd_pr__nfet_01v8 ad=3.36 pd=8 as=3.12 ps=7.6 w=1.2 l=0.6
X4 decision_p latch_sense_p_ext tail_ext vss_escape sky130_fd_pr__nfet_01v8 ad=3.36 pd=8 as=3.12 ps=7.6 w=1.2 l=0.6
X5 vdd_ext reset decision_n vdd_ext sky130_fd_pr__pfet_01v8 ad=3.12 pd=7.6 as=3.36 ps=8 w=1.2 l=0.6
X6 tail_ext latch_sense_n_ext decision_n vss_escape sky130_fd_pr__nfet_01v8 ad=3.12 pd=7.6 as=3.36 ps=8 w=1.2 l=0.6
X7 decision_p decision_n vdd_ext vdd_ext sky130_fd_pr__pfet_01v8 ad=3.36 pd=8 as=3.12 ps=7.6 w=1.2 l=0.6
X8 tail_ext decision_p decision_n vss_escape sky130_fd_pr__nfet_01v8 ad=3.12 pd=7.6 as=3.36 ps=8 w=1.2 l=0.6
X9 latch_sense_p_ext row_drive iso_tail_ext vss_escape sky130_fd_pr__nfet_01v8 ad=3.36 pd=8 as=3.12 ps=7.6 w=1.2 l=0.6
X10 iso_tail_ext sar_comparator_input latch_sense_n_ext vss_escape sky130_fd_pr__nfet_01v8 ad=3.12 pd=7.6 as=3.36 ps=8 w=1.2 l=0.6
X11 decision_p reset vdd_ext vdd_ext sky130_fd_pr__pfet_01v8 ad=3.36 pd=8 as=3.12 ps=7.6 w=1.2 l=0.6
X12 decision_p decision_n tail_ext vss_escape sky130_fd_pr__nfet_01v8 ad=3.36 pd=8 as=3.12 ps=7.6 w=1.2 l=0.6
C0 m2_64900_1400# m1_65180_1400# 0.13847f
C1 m1_65180_1400# vss 0.00102f
C2 vdd_ext decision_p 3.8282f
C3 row_drive latch_sense_p_ext 1.13418f
C4 latch_sense_p_ext decision_p 0.18428f
C5 shared_converter_mux_0.mux_bus vss 0.03132f
C6 vdd_ext eval 0
C7 row_drive row_dac_10b_0.vdd 1.11462f
C8 reset tail_ext 0.17577f
C9 latch_sense_n_ext vss 0.23985f
C10 shared_converter_mux_0.vss shared_converter_mux_0.mux_bus 1.56188f
C11 row_dac_10b_0.vss row_drive 1.08123f
C12 row_drive m2_64900_1400# 1.01939f
C13 row_drive vss 1.37456f
C14 m2_64900_1400# physical_preamp_0.preamp_iso_tail_ext 0.33769f
C15 sar_readout_12b_0.vdd iso_tail_ext 0.27521f
C16 sar_readout_12b_0.vss iso_tail_ext 0.60045f
C17 vdd_ext sar_readout_12b_0.vdd 1.39936f
C18 vdd_ext sar_readout_12b_0.vss 0.93663f
C19 reset decision_p 0.376f
C20 shared_converter_mux_0.vss row_drive 0.00246f
C21 sar_comparator_input iso_tail_ext 0.16721f
C22 vdd_ext sar_comparator_input 0.06859f
C23 shared_converter_mux_0.mux_bus shared_converter_mux_0.vdd 1.55306f
C24 tail_ext decision_n 0.48065f
C25 m1_68300_3080# m1_65180_1400# 0.12858f
C26 latch_sense_n_ext decision_n 0.18428f
C27 vdd_ext iso_tail_ext 0.3078f
C28 decision_p decision_n 2.54301f
C29 m2_64900_1400# sar_comparator_input 0.25407f
C30 sar_comparator_input vss 0.05708f
C31 latch_sense_p_ext iso_tail_ext 0.21294f
C32 shared_converter_mux_0.vdd row_drive 0.00246f
C33 m1_68300_3080# row_drive 3.96573f
C34 m1_68300_3080# physical_preamp_0.preamp_iso_tail_ext 0.01748f
C35 row_drive m1_65180_1400# 0.94669f
C36 physical_preamp_0.preamp_iso_tail_ext m1_65180_1400# 0.14439f
C37 vdd_ext vss 0.19458f
C38 vdd_ext reset 4.48789f
C39 latch_sense_p_ext vss 0.23483f
C40 shared_converter_mux_0.mux_bus row_drive 0.06281f
C41 latch_sense_n_ext tail_ext 0.0334f
C42 shared_converter_mux_0.vss vdd_ext 0
C43 row_dac_10b_0.vss row_dac_10b_0.vdd 0.78467f
C44 tail_ext decision_p 0.48065f
C45 row_drive latch_sense_n_ext 1.06835f
C46 row_drive physical_preamp_0.preamp_iso_tail_ext 0.69412f
C47 tail_ext eval 0.36751f
C48 m1_68300_3080# sar_comparator_input 0.05518f
C49 vdd_ext decision_n 3.9382f
C50 sar_comparator_input m1_65180_1400# 0.00413f
C51 shared_converter_mux_0.vdd vdd_ext 0
C52 row_drive vdd 0.1964f
C53 row_drive sar_readout_12b_0.vdd 0.58157f
C54 row_drive sar_readout_12b_0.vss 0.29433f
C55 m1_68300_3080# vdd_ext 0.15428f
C56 latch_sense_n_ext sar_comparator_input 0.23009f
C57 row_drive sar_comparator_input 6.29852f
C58 sar_comparator_input physical_preamp_0.preamp_iso_tail_ext 0.20221f
C59 reset decision_n 0.31048f
C60 shared_converter_mux_0.vdd vss 0.2816f
C61 shared_converter_mux_0.mux_bus vdd_ext 0.00217f
C62 vdd_ext tail_ext 1.9856f
C63 m1_68300_3080# m2_64900_1400# 0
C64 latch_sense_n_ext iso_tail_ext 0.21209f
C65 sar_readout_12b_0.vdd sar_readout_12b_0.vss 0.49712f
C66 latch_sense_p_ext tail_ext 0.0334f
C67 row_drive iso_tail_ext 2.39704f
C68 row_drive vdd_ext 2.91195f
C69 vss vss_escape 36.2292f
C70 vdd vss_escape 36.7f
C71 iso_tail_ext vss_escape 20.9682f
C72 decision_p vss_escape 7.71981f
C73 tail_ext vss_escape 83.89029f
C74 vdd_ext vss_escape 0.23925p
C75 m2_64900_1400# vss_escape 0.64899f ; **FLOATING
C76 sar_readout_12b_0.vss vss_escape 1.33686f ; **FLOATING
C77 row_dac_10b_0.vss vss_escape 1.40333f ; **FLOATING
C78 row_dac_10b_0.vdd vss_escape 1.33457f ; **FLOATING
C79 sar_readout_12b_0.vdd vss_escape 1.77614f ; **FLOATING
C80 m1_65180_1400# vss_escape 0.83876f ; **FLOATING
C81 m1_68300_3080# vss_escape 7.90194f ; **FLOATING
C82 shared_converter_mux_0.vss vss_escape 1.39454f ; **FLOATING
C83 shared_converter_mux_0.mux_bus vss_escape 2.86922f ; **FLOATING
C84 shared_converter_mux_0.vdd vss_escape 0.95985f ; **FLOATING
C85 physical_preamp_0.preamp_iso_tail_ext vss_escape 0.11036p
.ends
