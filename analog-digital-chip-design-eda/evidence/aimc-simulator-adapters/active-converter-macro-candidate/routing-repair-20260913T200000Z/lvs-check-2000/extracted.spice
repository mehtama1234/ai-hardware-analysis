* NGSPICE file created from aimc_converter_macro_active_candidate_flat.ext - technology: sky130A

.subckt aimc_converter_macro_active_candidate_flat vss vdd row_drive sar_comparator_input
+ decision_p decision_n reset eval vss_escape latch_sense_p_ext latch_sense_n_ext
+ iso_tail_ext tail_ext vdd_ext
X0 physical_preamp_0.iso_tail physical_preamp_0.sense_n physical_preamp_0.iso_n vss_escape sky130_fd_pr__nfet_01v8 ad=3.12 pd=7.6 as=3.36 ps=8 w=1.2 l=0.6
X1 vdd_ext decision_p decision_n vdd_ext sky130_fd_pr__pfet_01v8 ad=3.12 pd=7.6 as=3.36 ps=8 w=1.2 l=0.6
X2 tail_ext eval vss_escape vss_escape sky130_fd_pr__nfet_01v8 ad=16.2 pd=17.4 as=16.2 ps=17.4 w=6 l=0.6
X3 physical_preamp_0.iso_p physical_preamp_0.sense_p physical_preamp_0.iso_tail vss_escape sky130_fd_pr__nfet_01v8 ad=3.36 pd=8 as=3.12 ps=7.6 w=1.2 l=0.6
X4 decision_p latch_sense_p_ext tail_ext vss_escape sky130_fd_pr__nfet_01v8 ad=3.36 pd=8 as=3.12 ps=7.6 w=1.2 l=0.6
X5 vdd_ext reset decision_n vdd_ext sky130_fd_pr__pfet_01v8 ad=3.12 pd=7.6 as=3.36 ps=8 w=1.2 l=0.6
X6 tail_ext latch_sense_n_ext decision_n vss_escape sky130_fd_pr__nfet_01v8 ad=3.12 pd=7.6 as=3.36 ps=8 w=1.2 l=0.6
X7 decision_p decision_n vdd_ext vdd_ext sky130_fd_pr__pfet_01v8 ad=3.36 pd=8 as=3.12 ps=7.6 w=1.2 l=0.6
X8 tail_ext decision_p decision_n vss_escape sky130_fd_pr__nfet_01v8 ad=3.12 pd=7.6 as=3.36 ps=8 w=1.2 l=0.6
X9 latch_sense_p_ext row_drive iso_tail_ext vss_escape sky130_fd_pr__nfet_01v8 ad=3.36 pd=8 as=3.12 ps=7.6 w=1.2 l=0.6
X10 iso_tail_ext sar_comparator_input latch_sense_n_ext vss_escape sky130_fd_pr__nfet_01v8 ad=3.12 pd=7.6 as=3.36 ps=8 w=1.2 l=0.6
X11 decision_p reset vdd_ext vdd_ext sky130_fd_pr__pfet_01v8 ad=3.36 pd=8 as=3.12 ps=7.6 w=1.2 l=0.6
X12 decision_p decision_n tail_ext vss_escape sky130_fd_pr__nfet_01v8 ad=3.36 pd=8 as=3.12 ps=7.6 w=1.2 l=0.6
C0 shared_converter_mux_0.mux_bus vss 0.03132f
C1 vdd_ext physical_preamp_0.iso_tail 0.36834f
C2 m2_64900_1400# sar_comparator_input 0.1759f
C3 li_67560_3080# physical_preamp_0.iso_n 0
C4 vss latch_sense_n_ext 0.23329f
C5 li_67560_3080# row_drive 2.7609f
C6 shared_converter_mux_0.vdd row_drive 0.00246f
C7 li_67560_3080# physical_preamp_0.iso_tail 0.00653f
C8 sar_readout_12b_0.vss sar_readout_12b_0.vdd 0.49712f
C9 physical_preamp_0.sense_p row_drive 0.19241f
C10 m2_64900_1400# physical_preamp_0.sense_n 0.04189f
C11 iso_tail_ext sar_comparator_input 0.16721f
C12 iso_tail_ext latch_sense_p_ext 0.12577f
C13 physical_preamp_0.sense_p physical_preamp_0.iso_tail 0.13895f
C14 sar_readout_12b_0.vss row_drive 0.29433f
C15 vdd_ext vss 0.21361f
C16 latch_sense_p_ext tail_ext 0.0334f
C17 latch_sense_n_ext sar_comparator_input 0.04279f
C18 physical_preamp_0.iso_p sar_comparator_input 0.02717f
C19 shared_converter_mux_0.vss shared_converter_mux_0.mux_bus 1.56188f
C20 decision_n tail_ext 0.48065f
C21 latch_sense_n_ext decision_n 0.18428f
C22 physical_preamp_0.iso_n row_drive 0.00394f
C23 vdd_ext sar_comparator_input 1.05807f
C24 physical_preamp_0.iso_n physical_preamp_0.iso_tail 0.05314f
C25 sar_readout_12b_0.vdd row_drive 0.58157f
C26 vdd_ext latch_sense_p_ext 3.43095f
C27 shared_converter_mux_0.vdd vss 0.2816f
C28 latch_sense_p_ext decision_p 0.18428f
C29 physical_preamp_0.iso_tail row_drive 0.38216f
C30 vdd_ext decision_n 3.9382f
C31 decision_n decision_p 2.54301f
C32 m2_64900_1400# physical_preamp_0.iso_p 0.41846f
C33 vdd_ext physical_preamp_0.sense_n 0.02073f
C34 vdd_ext shared_converter_mux_0.vss 0
C35 m2_64900_1400# vdd_ext 0.08017f
C36 physical_preamp_0.sense_p sar_comparator_input 0.04049f
C37 iso_tail_ext latch_sense_n_ext 0.12577f
C38 row_dac_10b_0.vss row_drive 1.08123f
C39 vss row_drive 0.22445f
C40 li_67560_3080# physical_preamp_0.sense_n 0.10132f
C41 vdd_ext shared_converter_mux_0.mux_bus 0.00217f
C42 latch_sense_n_ext tail_ext 0.0334f
C43 vdd_ext iso_tail_ext 0.86179f
C44 m2_64900_1400# li_67560_3080# 0
C45 physical_preamp_0.iso_n sar_comparator_input 0.0285f
C46 physical_preamp_0.sense_p m2_64900_1400# 0.03788f
C47 vdd_ext tail_ext 1.9856f
C48 decision_p tail_ext 0.48065f
C49 vdd_ext latch_sense_n_ext 3.48444f
C50 sar_comparator_input row_drive 5.24644f
C51 vdd_ext physical_preamp_0.iso_p 0.06654f
C52 decision_n reset 0.31048f
C53 latch_sense_p_ext row_drive 0.6214f
C54 physical_preamp_0.iso_tail sar_comparator_input 0.03759f
C55 shared_converter_mux_0.vdd shared_converter_mux_0.mux_bus 1.55306f
C56 physical_preamp_0.iso_n physical_preamp_0.sense_n 0.02157f
C57 vdd_ext decision_p 3.8282f
C58 sar_readout_12b_0.vss iso_tail_ext 0.60045f
C59 physical_preamp_0.sense_n row_drive 0.09115f
C60 m2_64900_1400# physical_preamp_0.iso_n 0.41846f
C61 tail_ext eval 0.36751f
C62 shared_converter_mux_0.vss row_drive 0.00246f
C63 physical_preamp_0.sense_n physical_preamp_0.iso_tail 0.12781f
C64 li_67560_3080# physical_preamp_0.iso_p 0
C65 m2_64900_1400# row_drive 0.01663f
C66 physical_preamp_0.sense_p physical_preamp_0.iso_p 0.02157f
C67 m2_64900_1400# physical_preamp_0.iso_tail 0.34303f
C68 row_dac_10b_0.vdd row_drive 1.11462f
C69 vss latch_sense_p_ext 0.23329f
C70 li_67560_3080# vdd_ext 0.56505f
C71 vdd_ext eval 0
C72 shared_converter_mux_0.vdd vdd_ext 0
C73 physical_preamp_0.sense_p vdd_ext 0.04911f
C74 sar_readout_12b_0.vdd iso_tail_ext 0.27521f
C75 shared_converter_mux_0.mux_bus row_drive 0.06281f
C76 vdd_ext sar_readout_12b_0.vss 0.93663f
C77 iso_tail_ext row_drive 2.39704f
C78 reset tail_ext 0.17577f
C79 physical_preamp_0.iso_n physical_preamp_0.iso_p 0.00782f
C80 latch_sense_n_ext row_drive 0.57746f
C81 physical_preamp_0.iso_p row_drive 0.00526f
C82 physical_preamp_0.sense_p li_67560_3080# 0
C83 row_dac_10b_0.vdd row_dac_10b_0.vss 0.78467f
C84 vdd_ext reset 4.48789f
C85 physical_preamp_0.iso_n vdd_ext 0.03315f
C86 physical_preamp_0.iso_p physical_preamp_0.iso_tail 0.05347f
C87 decision_p reset 0.376f
C88 vdd_ext sar_readout_12b_0.vdd 1.39936f
C89 vdd row_drive 0.1964f
C90 vdd_ext row_drive 4.1652f
C91 physical_preamp_0.sense_n sar_comparator_input 0.07548f
C92 vss vss_escape 36.2211f
C93 vdd vss_escape 36.7f
C94 iso_tail_ext vss_escape 66.3001f
C95 latch_sense_n_ext vss_escape 8.9128f
C96 latch_sense_p_ext vss_escape 36.4191f
C97 decision_p vss_escape 7.38983f
C98 tail_ext vss_escape 81.08725f
C99 vdd_ext vss_escape 0.25911p
C100 m2_64900_1400# vss_escape 0.6863f ; **FLOATING
C101 sar_readout_12b_0.vss vss_escape 1.33686f ; **FLOATING
C102 row_dac_10b_0.vss vss_escape 1.40333f ; **FLOATING
C103 row_dac_10b_0.vdd vss_escape 1.33457f ; **FLOATING
C104 sar_readout_12b_0.vdd vss_escape 1.77614f ; **FLOATING
C105 shared_converter_mux_0.vss vss_escape 1.39454f ; **FLOATING
C106 shared_converter_mux_0.mux_bus vss_escape 2.86922f ; **FLOATING
C107 shared_converter_mux_0.vdd vss_escape 0.95985f ; **FLOATING
C108 li_67560_3080# vss_escape 8.17525f ; **FLOATING
C109 physical_preamp_0.iso_n vss_escape 1.39269f
C110 physical_preamp_0.iso_p vss_escape 1.21204f
C111 physical_preamp_0.iso_tail vss_escape 4.34048f
.ends
