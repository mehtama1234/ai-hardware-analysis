* NGSPICE file created from aimc_converter_macro_active_candidate_flat.ext - technology: sky130A

.subckt aimc_converter_macro_active_candidate_flat vss vdd row_drive sar_comparator_input
+ decision_p decision_n reset eval vss_escape latch_sense_p_ext latch_sense_n_ext
+ iso_tail_ext tail_ext vdd_ext preamp_iso_tail_ext
X0 preamp_iso_tail_ext sar_comparator_input latch_sense_n_ext_uq0 vss_escape sky130_fd_pr__nfet_01v8 ad=3.12 pd=7.6 as=3.36 ps=8 w=1.2 l=0.6
X1 vdd_ext decision_p decision_n vdd_ext sky130_fd_pr__pfet_01v8 ad=3.12 pd=7.6 as=3.36 ps=8 w=1.2 l=0.6
X2 tail_ext eval vss_escape vss_escape sky130_fd_pr__nfet_01v8 ad=16.2 pd=17.4 as=16.2 ps=17.4 w=6 l=0.6
X3 latch_sense_p_ext_uq0 row_drive preamp_iso_tail_ext vss_escape sky130_fd_pr__nfet_01v8 ad=3.36 pd=8 as=3.12 ps=7.6 w=1.2 l=0.6
X4 decision_p latch_sense_p_ext tail_ext vss_escape sky130_fd_pr__nfet_01v8 ad=3.36 pd=8 as=3.12 ps=7.6 w=1.2 l=0.6
X5 vdd_ext reset decision_n vdd_ext sky130_fd_pr__pfet_01v8 ad=3.12 pd=7.6 as=3.36 ps=8 w=1.2 l=0.6
X6 tail_ext latch_sense_n_ext decision_n vss_escape sky130_fd_pr__nfet_01v8 ad=3.12 pd=7.6 as=3.36 ps=8 w=1.2 l=0.6
X7 decision_p decision_n vdd_ext vdd_ext sky130_fd_pr__pfet_01v8 ad=3.36 pd=8 as=3.12 ps=7.6 w=1.2 l=0.6
X8 tail_ext decision_p decision_n vss_escape sky130_fd_pr__nfet_01v8 ad=3.12 pd=7.6 as=3.36 ps=8 w=1.2 l=0.6
X9 latch_sense_p_ext row_drive iso_tail_ext vss_escape sky130_fd_pr__nfet_01v8 ad=3.36 pd=8 as=3.12 ps=7.6 w=1.2 l=0.6
X10 iso_tail_ext sar_comparator_input latch_sense_n_ext vss_escape sky130_fd_pr__nfet_01v8 ad=3.12 pd=7.6 as=3.36 ps=8 w=1.2 l=0.6
X11 decision_p reset vdd_ext vdd_ext sky130_fd_pr__pfet_01v8 ad=3.36 pd=8 as=3.12 ps=7.6 w=1.2 l=0.6
X12 decision_p decision_n tail_ext vss_escape sky130_fd_pr__nfet_01v8 ad=3.36 pd=8 as=3.12 ps=7.6 w=1.2 l=0.6
C0 row_dac_10b_0.vss row_dac_10b_0.vdd 0.78467f
C1 latch_sense_p_ext_uq0 row_drive 0.02765f
C2 vdd_ext eval 0
C3 sar_comparator_input row_drive 5.29847f
C4 tail_ext latch_sense_p_ext 0.0334f
C5 latch_sense_n_ext_uq0 preamp_iso_tail_ext 0.05717f
C6 m2_64900_1400# preamp_iso_tail_ext 0.34398f
C7 row_dac_10b_0.vdd row_drive 1.11462f
C8 row_drive latch_sense_p_ext 0.6214f
C9 row_dac_10b_0.vss row_drive 1.08123f
C10 vdd_ext preamp_iso_tail_ext 0.18336f
C11 m2_64900_1400# latch_sense_n_ext_uq0 0.41846f
C12 vss latch_sense_p_ext 0.23329f
C13 iso_tail_ext vdd_ext 0.86179f
C14 latch_sense_n_ext_uq0 vdd_ext 0.00673f
C15 shared_converter_mux_0.vss shared_converter_mux_0.mux_bus 1.56188f
C16 shared_converter_mux_0.mux_bus row_drive 0.06281f
C17 m2_64900_1400# vdd_ext 0.06307f
C18 sar_readout_12b_0.vss iso_tail_ext 0.60045f
C19 decision_p reset 0.376f
C20 reset vdd_ext 4.48789f
C21 shared_converter_mux_0.vss row_drive 0.00246f
C22 shared_converter_mux_0.mux_bus vss 0.03132f
C23 decision_p vdd_ext 3.8282f
C24 sar_readout_12b_0.vdd row_drive 0.58157f
C25 m1_68300_3080# preamp_iso_tail_ext 0.01748f
C26 shared_converter_mux_0.mux_bus shared_converter_mux_0.vdd 1.55306f
C27 iso_tail_ext latch_sense_n_ext 0.12577f
C28 vss row_drive 0.22445f
C29 latch_sense_p_ext_uq0 preamp_iso_tail_ext 0.05749f
C30 shared_converter_mux_0.vdd row_drive 0.00246f
C31 sar_readout_12b_0.vss vdd_ext 0.93663f
C32 preamp_iso_tail_ext sar_comparator_input 0.14938f
C33 tail_ext eval 0.36751f
C34 m1_68300_3080# latch_sense_n_ext_uq0 0
C35 shared_converter_mux_0.vdd vss 0.2816f
C36 m1_68300_3080# m2_64900_1400# 0
C37 iso_tail_ext sar_comparator_input 0.16721f
C38 vdd_ext latch_sense_n_ext 3.48444f
C39 latch_sense_p_ext_uq0 latch_sense_n_ext_uq0 0.00782f
C40 latch_sense_p_ext_uq0 m2_64900_1400# 0.41846f
C41 latch_sense_n_ext_uq0 sar_comparator_input 0.05007f
C42 m1_68300_3080# vdd_ext 0.24419f
C43 m2_64900_1400# sar_comparator_input 0.21578f
C44 reset decision_n 0.31048f
C45 decision_p decision_n 2.54301f
C46 latch_sense_p_ext_uq0 vdd_ext 0.01996f
C47 decision_n vdd_ext 3.9382f
C48 iso_tail_ext latch_sense_p_ext 0.12577f
C49 vdd_ext sar_comparator_input 1.05969f
C50 decision_p latch_sense_p_ext 0.18428f
C51 preamp_iso_tail_ext row_drive 0.35661f
C52 vdd_ext latch_sense_p_ext 3.43095f
C53 decision_n latch_sense_n_ext 0.18428f
C54 reset tail_ext 0.17577f
C55 sar_comparator_input latch_sense_n_ext 0.04279f
C56 latch_sense_p_ext_uq0 m1_68300_3080# 0
C57 decision_p tail_ext 0.48065f
C58 sar_readout_12b_0.vdd iso_tail_ext 0.27521f
C59 iso_tail_ext row_drive 2.39704f
C60 tail_ext vdd_ext 1.9856f
C61 m1_68300_3080# sar_comparator_input 0
C62 latch_sense_n_ext_uq0 row_drive 0.00475f
C63 latch_sense_p_ext_uq0 sar_comparator_input 0.02717f
C64 m2_64900_1400# row_drive 0.05066f
C65 shared_converter_mux_0.mux_bus vdd_ext 0.00217f
C66 shared_converter_mux_0.vss vdd_ext 0
C67 sar_readout_12b_0.vdd vdd_ext 1.39936f
C68 vdd_ext row_drive 3.85718f
C69 tail_ext latch_sense_n_ext 0.0334f
C70 vdd_ext vss 0.19458f
C71 sar_readout_12b_0.vdd sar_readout_12b_0.vss 0.49712f
C72 sar_readout_12b_0.vss row_drive 0.29433f
C73 shared_converter_mux_0.vdd vdd_ext 0
C74 decision_n tail_ext 0.48065f
C75 row_drive latch_sense_n_ext 0.57746f
C76 vdd row_drive 0.1964f
C77 m1_68300_3080# row_drive 2.68356f
C78 vss latch_sense_n_ext 0.23329f
C79 vss vss_escape 36.2292f
C80 vdd vss_escape 36.7f
C81 preamp_iso_tail_ext vss_escape 49.36008f
C82 iso_tail_ext vss_escape 20.9682f
C83 decision_p vss_escape 7.38983f
C84 tail_ext vss_escape 81.08725f
C85 vdd_ext vss_escape 0.2571p
C86 m2_64900_1400# vss_escape 0.72762f ; **FLOATING
C87 sar_readout_12b_0.vss vss_escape 1.33686f ; **FLOATING
C88 row_dac_10b_0.vss vss_escape 1.40333f ; **FLOATING
C89 row_dac_10b_0.vdd vss_escape 1.33457f ; **FLOATING
C90 sar_readout_12b_0.vdd vss_escape 1.77614f ; **FLOATING
C91 m1_68300_3080# vss_escape 7.90194f ; **FLOATING
C92 shared_converter_mux_0.vss vss_escape 1.39454f ; **FLOATING
C93 shared_converter_mux_0.mux_bus vss_escape 2.86922f ; **FLOATING
C94 shared_converter_mux_0.vdd vss_escape 0.95985f ; **FLOATING
C95 latch_sense_n_ext_uq0 vss_escape 10.07028f
C96 latch_sense_p_ext_uq0 vss_escape 37.16722f
.ends
