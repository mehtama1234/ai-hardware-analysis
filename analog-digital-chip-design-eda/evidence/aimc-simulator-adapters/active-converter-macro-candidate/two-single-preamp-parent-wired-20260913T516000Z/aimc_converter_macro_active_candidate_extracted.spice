* NGSPICE file created from aimc_converter_macro_active_candidate_flat.ext - technology: sky130A

.subckt aimc_converter_macro_active_candidate_flat vss vdd row_drive sar_comparator_input
+ decision_p decision_n reset eval vss_escape latch_sense_p_ext latch_sense_n_ext
+ iso_tail_ext tail_ext vdd_ext
X0 latch_sense_n_ext physical_preamp_n.sar_comparator_input preamp_iso_tail_ext vss_escape sky130_fd_pr__nfet_01v8 ad=3.36 pd=8 as=3.12 ps=7.6 w=1.2 l=0.6
X1 vdd_ext decision_p decision_n vdd_ext sky130_fd_pr__pfet_01v8 ad=3.12 pd=7.6 as=3.36 ps=8 w=1.2 l=0.6
X2 tail_ext eval vss_escape vss_escape sky130_fd_pr__nfet_01v8 ad=16.2 pd=17.4 as=16.2 ps=17.4 w=6 l=0.6
X3 decision_p latch_sense_p_ext tail_ext vss_escape sky130_fd_pr__nfet_01v8 ad=3.36 pd=8 as=3.12 ps=7.6 w=1.2 l=0.6
X4 vdd_ext reset decision_n vdd_ext sky130_fd_pr__pfet_01v8 ad=3.12 pd=7.6 as=3.36 ps=8 w=1.2 l=0.6
X5 tail_ext latch_sense_n_ext decision_n vss_escape sky130_fd_pr__nfet_01v8 ad=3.12 pd=7.6 as=3.36 ps=8 w=1.2 l=0.6
X6 decision_p decision_n vdd_ext vdd_ext sky130_fd_pr__pfet_01v8 ad=3.36 pd=8 as=3.12 ps=7.6 w=1.2 l=0.6
X7 tail_ext decision_p decision_n vss_escape sky130_fd_pr__nfet_01v8 ad=3.12 pd=7.6 as=3.36 ps=8 w=1.2 l=0.6
X8 latch_sense_p_ext row_drive iso_tail_ext vss_escape sky130_fd_pr__nfet_01v8 ad=3.36 pd=8 as=3.12 ps=7.6 w=1.2 l=0.6
X9 iso_tail_ext sar_comparator_input latch_sense_n_ext vss_escape sky130_fd_pr__nfet_01v8 ad=3.12 pd=7.6 as=3.36 ps=8 w=1.2 l=0.6
X10 latch_sense_p_ext row_drive preamp_iso_tail_ext vss_escape sky130_fd_pr__nfet_01v8 ad=3.36 pd=8 as=3.12 ps=7.6 w=1.2 l=0.6
X11 decision_p reset vdd_ext vdd_ext sky130_fd_pr__pfet_01v8 ad=3.36 pd=8 as=3.12 ps=7.6 w=1.2 l=0.6
X12 decision_p decision_n tail_ext vss_escape sky130_fd_pr__nfet_01v8 ad=3.36 pd=8 as=3.12 ps=7.6 w=1.2 l=0.6
C0 reset decision_p 0.376f
C1 sar_readout_12b_0.vdd vdd_ext 1.39936f
C2 physical_preamp_n.sar_comparator_input preamp_iso_tail_ext 0.09492f
C3 reset vdd_ext 4.48789f
C4 sar_comparator_input latch_sense_n_ext 0.04367f
C5 iso_tail_ext latch_sense_p_ext 0.1295f
C6 physical_preamp_n.sar_comparator_input m4_45060_36440# 0.00629f
C7 physical_preamp_n.sar_comparator_input m4_51060_36440# 0.0704f
C8 iso_tail_ext row_drive 2.39704f
C9 tail_ext eval 0.36751f
C10 latch_sense_n_ext vdd_ext 4.55721f
C11 latch_sense_p_ext eval 0.19752f
C12 sar_comparator_input vdd_ext 1.06679f
C13 row_dac_10b_0.vss row_drive 1.08123f
C14 decision_p vdd_ext 3.8282f
C15 shared_converter_mux_0.vdd row_drive 0.00246f
C16 shared_converter_mux_0.mux_bus row_drive 0.06281f
C17 row_dac_10b_0.vss row_dac_10b_0.vdd 0.78467f
C18 iso_tail_ext sar_readout_12b_0.vss 0.60045f
C19 vss latch_sense_n_ext 0.29037f
C20 physical_preamp_n.sar_comparator_input latch_sense_n_ext 0.1507f
C21 shared_converter_mux_0.vss row_drive 0.00246f
C22 iso_tail_ext sar_readout_12b_0.vdd 0.27521f
C23 m4_32000_38940# latch_sense_n_ext 0.0096f
C24 decision_n tail_ext 0.48065f
C25 vss vdd_ext 0.19458f
C26 m1_68300_3080# vdd_ext 0.24419f
C27 row_drive m2_42000_41940# 0.12051f
C28 physical_preamp_n.sar_comparator_input vdd_ext 0.17176f
C29 iso_tail_ext latch_sense_n_ext 0.12999f
C30 iso_tail_ext sar_comparator_input 0.16721f
C31 vdd row_drive 0.1964f
C32 tail_ext latch_sense_p_ext 0.99589f
C33 iso_tail_ext vdd_ext 0.86179f
C34 row_drive latch_sense_p_ext 1.30923f
C35 eval vdd_ext 0
C36 preamp_iso_tail_ext latch_sense_p_ext 0.28327f
C37 reset decision_n 0.31048f
C38 shared_converter_mux_0.vdd vdd_ext 0
C39 shared_converter_mux_0.mux_bus vdd_ext 0.00217f
C40 preamp_iso_tail_ext row_drive 0.07646f
C41 m4_45060_36440# latch_sense_p_ext 0.00708f
C42 row_dac_10b_0.vdd row_drive 1.11462f
C43 decision_n latch_sense_n_ext 0.37635f
C44 m4_45060_36440# row_drive 0.10035f
C45 shared_converter_mux_0.vss vdd_ext 0
C46 row_drive sar_readout_12b_0.vss 0.29433f
C47 shared_converter_mux_0.vdd vss 0.2816f
C48 m4_45060_36440# preamp_iso_tail_ext 0
C49 reset tail_ext 0.17577f
C50 shared_converter_mux_0.mux_bus vss 0.03132f
C51 m4_51060_36440# preamp_iso_tail_ext 0.00179f
C52 reset latch_sense_p_ext 0.19529f
C53 decision_n decision_p 2.54301f
C54 decision_n vdd_ext 3.9382f
C55 sar_readout_12b_0.vdd row_drive 0.58157f
C56 latch_sense_n_ext tail_ext 1.09601f
C57 latch_sense_n_ext latch_sense_p_ext 0.59927f
C58 latch_sense_n_ext row_drive 0.83022f
C59 tail_ext decision_p 0.48065f
C60 sar_comparator_input row_drive 5.22878f
C61 decision_p latch_sense_p_ext 0.37635f
C62 tail_ext vdd_ext 1.9856f
C63 sar_readout_12b_0.vdd sar_readout_12b_0.vss 0.49712f
C64 latch_sense_p_ext vdd_ext 5.38438f
C65 preamp_iso_tail_ext latch_sense_n_ext 0.36983f
C66 row_drive vdd_ext 5.04789f
C67 m4_45060_36440# latch_sense_n_ext 0.00655f
C68 shared_converter_mux_0.vdd shared_converter_mux_0.mux_bus 1.55306f
C69 m4_51060_36440# latch_sense_n_ext 0.00671f
C70 preamp_iso_tail_ext vdd_ext 0.01021f
C71 vss latch_sense_p_ext 0.29037f
C72 m4_45060_36440# vdd_ext 0.01404f
C73 shared_converter_mux_0.mux_bus shared_converter_mux_0.vss 1.56188f
C74 physical_preamp_n.sar_comparator_input latch_sense_p_ext 0.09028f
C75 m4_51060_36440# vdd_ext 0.01404f
C76 vss row_drive 0.22445f
C77 m4_32000_38940# latch_sense_p_ext 0.00354f
C78 sar_readout_12b_0.vss vdd_ext 0.93663f
C79 m1_68300_3080# row_drive 2.68328f
C80 physical_preamp_n.sar_comparator_input row_drive 0.71865f
C81 vss vss_escape 36.2394f
C82 vdd vss_escape 36.7f
C83 iso_tail_ext vss_escape 84.72649f
C84 decision_p vss_escape 12.19531f
C85 tail_ext vss_escape 0.1212p
C86 latch_sense_n_ext vss_escape 9.0153f
C87 latch_sense_p_ext vss_escape 54.743f
C88 vdd_ext vss_escape 0.25981p
C89 m4_51060_36440# vss_escape 0.12744f ; **FLOATING
C90 m4_45060_36440# vss_escape 0.09034f ; **FLOATING
C91 m4_32000_38940# vss_escape 0.1568f ; **FLOATING
C92 m2_42000_41940# vss_escape 3.91591f ; **FLOATING
C93 sar_readout_12b_0.vss vss_escape 1.33686f ; **FLOATING
C94 row_dac_10b_0.vss vss_escape 1.40333f ; **FLOATING
C95 row_dac_10b_0.vdd vss_escape 1.33457f ; **FLOATING
C96 sar_readout_12b_0.vdd vss_escape 1.77614f ; **FLOATING
C97 m1_68300_3080# vss_escape 7.89552f ; **FLOATING
C98 shared_converter_mux_0.vss vss_escape 1.39454f ; **FLOATING
C99 shared_converter_mux_0.mux_bus vss_escape 2.86922f ; **FLOATING
C100 shared_converter_mux_0.vdd vss_escape 0.95985f ; **FLOATING
C101 preamp_iso_tail_ext vss_escape 7.44563f
.ends
