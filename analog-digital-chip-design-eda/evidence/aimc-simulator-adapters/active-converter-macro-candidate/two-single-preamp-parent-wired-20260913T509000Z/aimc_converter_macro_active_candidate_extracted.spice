* NGSPICE file created from aimc_converter_macro_active_candidate_flat.ext - technology: sky130A

.subckt aimc_converter_macro_active_candidate_flat vss vdd row_drive sar_comparator_input
+ decision_p decision_n reset eval vss_escape latch_sense_p_ext latch_sense_n_ext
+ iso_tail_ext tail_ext vdd_ext
X0 physical_preamp_n.latch_sense_n_ext physical_preamp_n.sar_comparator_input preamp_iso_tail_ext vss_escape sky130_fd_pr__nfet_01v8 ad=3.36 pd=8 as=3.12 ps=7.6 w=1.2 l=0.6
X1 vdd_ext decision_p decision_n vdd_ext sky130_fd_pr__pfet_01v8 ad=3.12 pd=7.6 as=3.36 ps=8 w=1.2 l=0.6
X2 tail_ext eval vss_escape vss_escape sky130_fd_pr__nfet_01v8 ad=16.2 pd=17.4 as=16.2 ps=17.4 w=6 l=0.6
X3 decision_p latch_sense_p_ext tail_ext vss_escape sky130_fd_pr__nfet_01v8 ad=3.36 pd=8 as=3.12 ps=7.6 w=1.2 l=0.6
X4 vdd_ext reset decision_n vdd_ext sky130_fd_pr__pfet_01v8 ad=3.12 pd=7.6 as=3.36 ps=8 w=1.2 l=0.6
X5 tail_ext latch_sense_n_ext decision_n vss_escape sky130_fd_pr__nfet_01v8 ad=3.12 pd=7.6 as=3.36 ps=8 w=1.2 l=0.6
X6 decision_p decision_n vdd_ext vdd_ext sky130_fd_pr__pfet_01v8 ad=3.36 pd=8 as=3.12 ps=7.6 w=1.2 l=0.6
X7 tail_ext decision_p decision_n vss_escape sky130_fd_pr__nfet_01v8 ad=3.12 pd=7.6 as=3.36 ps=8 w=1.2 l=0.6
X8 latch_sense_p_ext row_drive iso_tail_ext vss_escape sky130_fd_pr__nfet_01v8 ad=3.36 pd=8 as=3.12 ps=7.6 w=1.2 l=0.6
X9 iso_tail_ext sar_comparator_input latch_sense_n_ext vss_escape sky130_fd_pr__nfet_01v8 ad=3.12 pd=7.6 as=3.36 ps=8 w=1.2 l=0.6
X10 latch_sense_p_ext row_drive physical_preamp_p.preamp_iso_tail_ext vss_escape sky130_fd_pr__nfet_01v8 ad=3.36 pd=8 as=3.12 ps=7.6 w=1.2 l=0.6
X11 decision_p reset vdd_ext vdd_ext sky130_fd_pr__pfet_01v8 ad=3.36 pd=8 as=3.12 ps=7.6 w=1.2 l=0.6
X12 decision_p decision_n tail_ext vss_escape sky130_fd_pr__nfet_01v8 ad=3.36 pd=8 as=3.12 ps=7.6 w=1.2 l=0.6
C0 reset vdd_ext 4.48789f
C1 m4_45060_36440# vdd_ext 0.01404f
C2 physical_preamp_p.preamp_iso_tail_ext row_drive 0.10062f
C3 shared_converter_mux_0.vss row_drive 0.00246f
C4 row_dac_10b_0.vss row_dac_10b_0.vdd 0.78467f
C5 sar_comparator_input iso_tail_ext 0.16721f
C6 sar_readout_12b_0.vss row_drive 0.29433f
C7 preamp_iso_tail_ext physical_preamp_n.latch_sense_n_ext 0.05767f
C8 preamp_iso_tail_ext_uq0 row_drive 0.39367f
C9 m4_45060_36440# physical_preamp_p.preamp_iso_tail_ext 0
C10 row_drive sar_readout_12b_0.vdd 0.58157f
C11 vss shared_converter_mux_0.mux_bus 0.03132f
C12 iso_tail_ext vdd_ext 0.86179f
C13 vdd_ext m4_51060_36440# 0.01404f
C14 preamp_iso_tail_ext_uq0 m4_45060_36440# 0.04404f
C15 shared_converter_mux_0.mux_bus row_drive 0.06281f
C16 physical_preamp_n.sar_comparator_input vdd_ext 0.01545f
C17 decision_n tail_ext 0.48065f
C18 vss row_drive 0.22445f
C19 decision_p latch_sense_p_ext 0.37635f
C20 sar_comparator_input latch_sense_n_ext 0.0435f
C21 tail_ext reset 0.17577f
C22 sar_readout_12b_0.vss iso_tail_ext 0.60045f
C23 latch_sense_n_ext vdd_ext 3.56622f
C24 iso_tail_ext sar_readout_12b_0.vdd 0.27521f
C25 physical_preamp_n.sar_comparator_input preamp_iso_tail_ext_uq0 0.25967f
C26 m1_68300_3080# vdd_ext 0.24419f
C27 m4_45060_36440# row_drive 0.12597f
C28 eval latch_sense_p_ext 0.19752f
C29 decision_n reset 0.31048f
C30 vdd_ext latch_sense_p_ext 5.38463f
C31 preamp_iso_tail_ext vdd_ext 0.00772f
C32 physical_preamp_n.latch_sense_n_ext vdd_ext 0.01216f
C33 physical_preamp_p.preamp_iso_tail_ext latch_sense_p_ext 0.10128f
C34 shared_converter_mux_0.vdd vdd_ext 0
C35 iso_tail_ext row_drive 2.39704f
C36 physical_preamp_n.sar_comparator_input row_drive 0.12269f
C37 preamp_iso_tail_ext_uq0 latch_sense_p_ext 0.24718f
C38 row_dac_10b_0.vss row_drive 1.08123f
C39 preamp_iso_tail_ext_uq0 preamp_iso_tail_ext 0.03226f
C40 latch_sense_n_ext tail_ext 0.0334f
C41 decision_p vdd_ext 3.8282f
C42 preamp_iso_tail_ext_uq0 physical_preamp_n.latch_sense_n_ext 0.08633f
C43 vss latch_sense_n_ext 0.23329f
C44 tail_ext latch_sense_p_ext 0.99589f
C45 latch_sense_n_ext row_drive 0.58017f
C46 sar_comparator_input vdd_ext 1.06679f
C47 latch_sense_n_ext decision_n 0.18428f
C48 vdd row_drive 0.1964f
C49 vss latch_sense_p_ext 0.29037f
C50 m1_68300_3080# row_drive 2.68328f
C51 eval vdd_ext 0
C52 row_drive latch_sense_p_ext 0.96452f
C53 shared_converter_mux_0.mux_bus shared_converter_mux_0.vdd 1.55306f
C54 physical_preamp_n.sar_comparator_input m4_51060_36440# 0.13059f
C55 vss shared_converter_mux_0.vdd 0.2816f
C56 reset latch_sense_p_ext 0.19529f
C57 m4_45060_36440# latch_sense_p_ext 0.00708f
C58 physical_preamp_p.preamp_iso_tail_ext vdd_ext 0.00299f
C59 shared_converter_mux_0.vdd row_drive 0.00246f
C60 tail_ext decision_p 0.48065f
C61 shared_converter_mux_0.vss vdd_ext 0
C62 latch_sense_n_ext iso_tail_ext 0.12884f
C63 sar_readout_12b_0.vss vdd_ext 0.93663f
C64 preamp_iso_tail_ext_uq0 vdd_ext 0.14507f
C65 sar_readout_12b_0.vdd vdd_ext 1.39936f
C66 row_drive row_dac_10b_0.vdd 1.11462f
C67 decision_n decision_p 2.54301f
C68 iso_tail_ext latch_sense_p_ext 0.1295f
C69 preamp_iso_tail_ext m4_51060_36440# 0.00179f
C70 shared_converter_mux_0.mux_bus vdd_ext 0.00217f
C71 tail_ext eval 0.36751f
C72 preamp_iso_tail_ext_uq0 physical_preamp_p.preamp_iso_tail_ext 0.03389f
C73 tail_ext vdd_ext 1.9856f
C74 decision_p reset 0.376f
C75 physical_preamp_n.sar_comparator_input preamp_iso_tail_ext 0.10062f
C76 sar_comparator_input row_drive 5.22878f
C77 physical_preamp_n.sar_comparator_input physical_preamp_n.latch_sense_n_ext 0.12076f
C78 vss vdd_ext 0.19458f
C79 sar_readout_12b_0.vss sar_readout_12b_0.vdd 0.49712f
C80 row_drive vdd_ext 3.83977f
C81 shared_converter_mux_0.vss shared_converter_mux_0.mux_bus 1.56188f
C82 decision_n vdd_ext 3.9382f
C83 vss vss_escape 36.2394f
C84 vdd vss_escape 36.7f
C85 iso_tail_ext vss_escape 77.07605f
C86 latch_sense_n_ext vss_escape 9.0153f
C87 decision_p vss_escape 10.63038f
C88 tail_ext vss_escape 0.10379p
C89 latch_sense_p_ext vss_escape 47.09255f
C90 vdd_ext vss_escape 0.25387p
C91 m4_51060_36440# vss_escape 0.13014f ; **FLOATING
C92 m4_45060_36440# vss_escape 0.09675f ; **FLOATING
C93 preamp_iso_tail_ext_uq0 vss_escape 16.8686f ; **FLOATING
C94 sar_readout_12b_0.vss vss_escape 1.33686f ; **FLOATING
C95 row_dac_10b_0.vss vss_escape 1.40333f ; **FLOATING
C96 row_dac_10b_0.vdd vss_escape 1.33457f ; **FLOATING
C97 sar_readout_12b_0.vdd vss_escape 1.77614f ; **FLOATING
C98 m1_68300_3080# vss_escape 7.89552f ; **FLOATING
C99 shared_converter_mux_0.vss vss_escape 1.39454f ; **FLOATING
C100 shared_converter_mux_0.mux_bus vss_escape 2.86922f ; **FLOATING
C101 shared_converter_mux_0.vdd vss_escape 0.95985f ; **FLOATING
C102 physical_preamp_n.latch_sense_n_ext vss_escape 5.86244f
C103 preamp_iso_tail_ext vss_escape 4.51515f
C104 physical_preamp_p.preamp_iso_tail_ext vss_escape 0.38054f
.ends
