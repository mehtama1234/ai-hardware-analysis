* NGSPICE file created from aimc_converter_macro_active_candidate.ext - technology: sky130A

.subckt sky130_transistor_active_isolation_pair iso_tail iso_p iso_n sense_p sense_n
+ m1_3440_500# m1_1000_500# m2_900_1400# VSUBS
X0 iso_tail sense_n iso_n VSUBS sky130_fd_pr__nfet_01v8 ad=3.12 pd=7.6 as=3.36 ps=8 w=1.2 l=0.6
X1 iso_p sense_p iso_tail VSUBS sky130_fd_pr__nfet_01v8 ad=3.36 pd=8 as=3.12 ps=7.6 w=1.2 l=0.6
C0 m2_900_1400# m1_3440_500# 0.01113f
C1 iso_n m1_3440_500# 0.0015f
C2 m2_900_1400# iso_n 0.41846f
C3 m2_900_1400# m1_1000_500# 0.01113f
C4 sense_n iso_tail 0.11179f
C5 sense_n m1_3440_500# 0.04555f
C6 sense_n m2_900_1400# 0.04273f
C7 sense_n iso_n 0.02157f
C8 sense_p iso_p 0.02157f
C9 iso_tail iso_p 0.05749f
C10 iso_tail sense_p 0.12292f
C11 m2_900_1400# iso_p 0.41846f
C12 iso_n iso_p 0.00782f
C13 m1_1000_500# iso_p 0.0015f
C14 m2_900_1400# sense_p 0.04273f
C15 iso_tail m1_3440_500# 0.0015f
C16 sense_p m1_1000_500# 0.04555f
C17 m2_900_1400# iso_tail 0.34398f
C18 iso_n iso_tail 0.05717f
C19 iso_tail m1_1000_500# 0.0015f
C20 iso_n VSUBS 1.04634f
C21 iso_p VSUBS 1.04634f
C22 iso_tail VSUBS 4.24257f
C23 m2_900_1400# VSUBS 1.01648f
C24 m1_3440_500# VSUBS 0.31893f
C25 m1_1000_500# VSUBS 0.31893f
.ends

.subckt escaped_input_latch out_p out_n latch_sense_p latch_sense_n tail reset vdd
+ vss eval sense_p sense_n iso_tail vdd_active
X0 out_p out_n vdd_active vdd_active sky130_fd_pr__pfet_01v8 ad=3.36 pd=8 as=3.12 ps=7.6 w=1.2 l=0.6
X1 vdd reset out_n vdd sky130_fd_pr__pfet_01v8 ad=3.12 pd=7.6 as=3.36 ps=8 w=1.2 l=0.6
X2 tail out_p out_n vss sky130_fd_pr__nfet_01v8 ad=3.12 pd=7.6 as=3.36 ps=8 w=1.2 l=0.6
X3 out_p reset vdd vdd sky130_fd_pr__pfet_01v8 ad=3.36 pd=8 as=3.12 ps=7.6 w=1.2 l=0.6
X4 out_p out_n tail vss sky130_fd_pr__nfet_01v8 ad=3.36 pd=8 as=3.12 ps=7.6 w=1.2 l=0.6
X5 tail latch_sense_n out_n vss sky130_fd_pr__nfet_01v8 ad=3.12 pd=7.6 as=3.36 ps=8 w=1.2 l=0.6
X6 tail eval vss vss sky130_fd_pr__nfet_01v8 ad=16.2 pd=17.4 as=16.2 ps=17.4 w=6 l=0.6
X7 out_p latch_sense_p tail vss sky130_fd_pr__nfet_01v8 ad=3.36 pd=8 as=3.12 ps=7.6 w=1.2 l=0.6
X8 iso_tail sense_n latch_sense_n vss sky130_fd_pr__nfet_01v8 ad=3.12 pd=7.6 as=3.36 ps=8 w=1.2 l=0.6
X9 vdd_active out_p out_n vdd_active sky130_fd_pr__pfet_01v8 ad=3.12 pd=7.6 as=3.36 ps=8 w=1.2 l=0.6
X10 latch_sense_p sense_p iso_tail vss sky130_fd_pr__nfet_01v8 ad=3.36 pd=8 as=3.12 ps=7.6 w=1.2 l=0.6
C0 latch_sense_p tail 0.0334f
C1 latch_sense_n iso_tail 0.20888f
C2 latch_sense_n sense_n 0.22977f
C3 vdd out_p 0.76206f
C4 vdd out_n 0.77104f
C5 latch_sense_p sense_p 0.22977f
C6 out_p out_n 2.54301f
C7 eval tail 0.35666f
C8 out_p latch_sense_p 0.18428f
C9 iso_tail sense_p 0.26105f
C10 latch_sense_p iso_tail 0.20888f
C11 latch_sense_n tail 0.0334f
C12 tail reset 0.16491f
C13 tail vdd_active 0.9938f
C14 sense_n iso_tail 0.10725f
C15 latch_sense_n out_n 0.18428f
C16 vdd reset 4.47121f
C17 out_p reset 0.376f
C18 out_n reset 0.31048f
C19 out_p vdd_active 3.06556f
C20 vdd_active out_n 3.16716f
C21 vdd tail 0.9918f
C22 out_p tail 0.46979f
C23 tail out_n 0.46979f
C24 iso_tail vss 29.23796f
C25 latch_sense_n vss 1.7693f
C26 latch_sense_p vss 1.56796f
C27 out_n vss 13.58747f
C28 tail vss 89.03816f
C29 vdd_active vss 90.11912f
C30 vdd vss 78.65506f
.ends

.subckt aimc_converter_macro_active_candidate vss vdd row_drive sar_comparator_input
+ decision_p decision_n reset eval vss_escape vdd_ext iso_tail_ext tail_ext preamp_iso_tail_ext
Xphysical_preamp_0 physical_preamp_0/iso_tail physical_preamp_0/iso_p physical_preamp_0/iso_n
+ physical_preamp_0/sense_p physical_preamp_0/sense_n sar_comparator_input row_drive
+ vdd_ext vss_escape sky130_transistor_active_isolation_pair
Xconverter_latch_0 decision_p decision_n vdd_ext vdd_ext tail_ext reset vdd_ext vss_escape
+ eval row_drive sar_comparator_input iso_tail_ext vdd_ext escaped_input_latch
C0 sar_comparator_input vdd_ext 0.97385f
C1 shared_converter_mux_0/vss vdd_ext 0
C2 sar_comparator_input physical_preamp_0/iso_n 0.027f
C3 sar_comparator_input iso_tail_ext 0.05996f
C4 eval tail_ext 0.01085f
C5 decision_n tail_ext 0.01085f
C6 row_drive shared_converter_mux_0/vdd 0.00246f
C7 physical_preamp_0/iso_p sar_comparator_input 0.02717f
C8 shared_converter_mux_0/mux_bus shared_converter_mux_0/vdd 1.55306f
C9 physical_preamp_0/sense_p sar_comparator_input 0.04049f
C10 row_drive shared_converter_mux_0/mux_bus 0.06281f
C11 m1_69940_2940# preamp_iso_tail_ext 0.03103f
C12 tail_ext decision_p 0.01085f
C13 vdd row_drive 0.1964f
C14 physical_preamp_0/iso_tail row_drive 0.02322f
C15 tail_ext reset 0.01085f
C16 row_drive row_dac_10b_0/vdd 1.11462f
C17 shared_converter_mux_0/vdd vdd_ext 0
C18 sar_readout_12b_0/vss row_drive 0.29422f
C19 row_drive vdd_ext 2.78404f
C20 shared_converter_mux_0/mux_bus vdd_ext 0.00217f
C21 row_drive sar_readout_12b_0/vdd 0.57218f
C22 physical_preamp_0/sense_n vdd_ext 0.01344f
C23 eval vdd_ext 0
C24 row_drive iso_tail_ext 1.71857f
C25 physical_preamp_0/iso_tail vdd_ext 0.24531f
C26 vdd_ext decision_p 0
C27 sar_readout_12b_0/vss vdd_ext 0.93663f
C28 row_drive row_dac_10b_0/vss 1.08123f
C29 sar_readout_12b_0/vss sar_readout_12b_0/vdd 0.49712f
C30 shared_converter_mux_0/vdd vss 0.2816f
C31 sar_readout_12b_0/vdd vdd_ext 1.39936f
C32 physical_preamp_0/iso_p row_drive -0
C33 row_drive vss 0.22445f
C34 physical_preamp_0/sense_p row_drive 0.0365f
C35 shared_converter_mux_0/mux_bus vss 0.03132f
C36 reset vdd_ext 0.01669f
C37 sar_comparator_input row_drive 5.23145f
C38 row_drive shared_converter_mux_0/vss 0.00246f
C39 sar_readout_12b_0/vss iso_tail_ext 0.60045f
C40 sar_comparator_input physical_preamp_0/sense_n 0.02993f
C41 shared_converter_mux_0/mux_bus shared_converter_mux_0/vss 1.56188f
C42 physical_preamp_0/iso_n vdd_ext 0.07278f
C43 iso_tail_ext vdd_ext 0.48802f
C44 sar_readout_12b_0/vdd iso_tail_ext 0.27521f
C45 physical_preamp_0/iso_tail sar_comparator_input 0.0361f
C46 row_dac_10b_0/vss row_dac_10b_0/vdd 0.78467f
C47 physical_preamp_0/iso_p vdd_ext 0.09631f
C48 vss vdd_ext 0.66116f
C49 physical_preamp_0/sense_p vdd_ext 0.02997f
C50 preamp_iso_tail_ext vss_escape 0.18641f
C51 vss vss_escape 36.7f
C52 vdd vss_escape 36.7f
C53 m1_69940_2940# vss_escape 0.19727f ; **FLOATING
C54 iso_tail_ext vss_escape -1.05232f
C55 sar_comparator_input vss_escape 10.29191f
C56 decision_n vss_escape 3.8093f
C57 eval vss_escape 0.78348f
C58 row_drive vss_escape 19.1035f
C59 vdd_ext vss_escape 43.71414f
.ends
