* NGSPICE file created from aimc_converter_macro_active_candidate_flat.ext - technology: sky130A

.subckt aimc_converter_macro_active_candidate_flat vss vdd row_drive sar_comparator_input
+ decision_p decision_n reset eval vss_escape latch_sense_p_ext iso_tail_ext tail_ext
+ vdd_ext latch_sense_n_ext_uq1
X0 latch_sense_n_ext physical_preamp_n.sar_comparator_input latch_sense_n_ext_uq1 vss_escape sky130_fd_pr__nfet_01v8 ad=3.36 pd=8 as=3.12 ps=7.6 w=1.2 l=0.6
X1 vdd_ext decision_p decision_n vdd_ext sky130_fd_pr__pfet_01v8 ad=3.12 pd=7.6 as=3.36 ps=8 w=1.2 l=0.6
X2 tail_ext eval vss_escape vss_escape sky130_fd_pr__nfet_01v8 ad=16.2 pd=17.4 as=16.2 ps=17.4 w=6 l=0.6
X3 decision_p latch_sense_p_ext tail_ext vss_escape sky130_fd_pr__nfet_01v8 ad=3.36 pd=8 as=3.12 ps=7.6 w=1.2 l=0.6
X4 vdd_ext reset decision_n vdd_ext sky130_fd_pr__pfet_01v8 ad=3.12 pd=7.6 as=3.36 ps=8 w=1.2 l=0.6
X5 tail_ext latch_sense_n_ext_uq1 decision_n vss_escape sky130_fd_pr__nfet_01v8 ad=3.12 pd=7.6 as=3.36 ps=8 w=1.2 l=0.6
X6 decision_p decision_n vdd_ext vdd_ext sky130_fd_pr__pfet_01v8 ad=3.36 pd=8 as=3.12 ps=7.6 w=1.2 l=0.6
X7 tail_ext decision_p decision_n vss_escape sky130_fd_pr__nfet_01v8 ad=3.12 pd=7.6 as=3.36 ps=8 w=1.2 l=0.6
X8 latch_sense_p_ext row_drive iso_tail_ext vss_escape sky130_fd_pr__nfet_01v8 ad=3.36 pd=8 as=3.12 ps=7.6 w=1.2 l=0.6
X9 iso_tail_ext sar_comparator_input latch_sense_n_ext_uq1 vss_escape sky130_fd_pr__nfet_01v8 ad=3.12 pd=7.6 as=3.36 ps=8 w=1.2 l=0.6
X10 physical_preamp_p.latch_sense_p_ext row_drive latch_sense_n_ext_uq1 vss_escape sky130_fd_pr__nfet_01v8 ad=3.36 pd=8 as=3.12 ps=7.6 w=1.2 l=0.6
X11 decision_p reset vdd_ext vdd_ext sky130_fd_pr__pfet_01v8 ad=3.36 pd=8 as=3.12 ps=7.6 w=1.2 l=0.6
X12 decision_p decision_n tail_ext vss_escape sky130_fd_pr__nfet_01v8 ad=3.36 pd=8 as=3.12 ps=7.6 w=1.2 l=0.6
C0 m1_68300_3080# vdd_ext 0.24419f
C1 physical_preamp_n.sar_comparator_input vdd_ext 0.01545f
C2 sar_readout_12b_0.vss row_drive 0.29433f
C3 m4_51060_36440# vdd_ext 0.01404f
C4 vss latch_sense_p_ext 0.29037f
C5 sar_readout_12b_0.vdd row_drive 0.58157f
C6 latch_sense_p_ext row_drive 0.70701f
C7 physical_preamp_n.sar_comparator_input latch_sense_n_ext_uq1 0.38422f
C8 vss vdd_ext 0.19458f
C9 m4_51060_36440# latch_sense_n_ext_uq1 0.00179f
C10 latch_sense_p_ext decision_p 0.37635f
C11 row_drive vdd_ext 3.84053f
C12 vdd row_drive 0.1964f
C13 decision_p vdd_ext 3.8282f
C14 decision_n tail_ext 0.48065f
C15 reset decision_p 0.376f
C16 latch_sense_n_ext vdd_ext 0.01216f
C17 vss latch_sense_n_ext_uq1 0.29037f
C18 shared_converter_mux_0.vdd vdd_ext 0
C19 sar_comparator_input row_drive 5.22878f
C20 iso_tail_ext sar_readout_12b_0.vss 0.60045f
C21 latch_sense_n_ext_uq1 row_drive 1.18654f
C22 eval tail_ext 0.36751f
C23 physical_preamp_n.sar_comparator_input m4_51060_36440# 0.13059f
C24 shared_converter_mux_0.mux_bus vdd_ext 0.00217f
C25 sar_readout_12b_0.vdd iso_tail_ext 0.27521f
C26 latch_sense_p_ext iso_tail_ext 0.1295f
C27 latch_sense_n_ext latch_sense_n_ext_uq1 0.15763f
C28 shared_converter_mux_0.vss row_drive 0.00246f
C29 m4_45060_36440# vdd_ext 0.01404f
C30 iso_tail_ext vdd_ext 0.86179f
C31 m1_68300_3080# row_drive 2.68328f
C32 physical_preamp_n.sar_comparator_input row_drive 0.12269f
C33 latch_sense_p_ext tail_ext 0.99589f
C34 iso_tail_ext sar_comparator_input 0.16721f
C35 physical_preamp_n.sar_comparator_input latch_sense_n_ext 0.1174f
C36 m4_45060_36440# latch_sense_n_ext_uq1 0.04583f
C37 iso_tail_ext latch_sense_n_ext_uq1 0.12999f
C38 decision_n vdd_ext 3.9382f
C39 latch_sense_p_ext eval 0.19752f
C40 vss row_drive 0.22445f
C41 shared_converter_mux_0.vss shared_converter_mux_0.mux_bus 1.56188f
C42 tail_ext vdd_ext 1.9856f
C43 reset decision_n 0.31048f
C44 reset tail_ext 0.17577f
C45 row_dac_10b_0.vss row_drive 1.08123f
C46 eval vdd_ext 0
C47 vss shared_converter_mux_0.vdd 0.2816f
C48 decision_n latch_sense_n_ext_uq1 0.37635f
C49 physical_preamp_p.latch_sense_p_ext vdd_ext 0.01185f
C50 sar_readout_12b_0.vdd sar_readout_12b_0.vss 0.49712f
C51 shared_converter_mux_0.vdd row_drive 0.00246f
C52 tail_ext latch_sense_n_ext_uq1 1.09601f
C53 vss shared_converter_mux_0.mux_bus 0.03132f
C54 shared_converter_mux_0.mux_bus row_drive 0.06281f
C55 sar_readout_12b_0.vss vdd_ext 0.93663f
C56 physical_preamp_p.latch_sense_p_ext latch_sense_n_ext_uq1 0.09914f
C57 sar_readout_12b_0.vdd vdd_ext 1.39936f
C58 m4_45060_36440# row_drive 0.13059f
C59 shared_converter_mux_0.vdd shared_converter_mux_0.mux_bus 1.55306f
C60 latch_sense_p_ext vdd_ext 4.11646f
C61 iso_tail_ext row_drive 2.39704f
C62 latch_sense_p_ext reset 0.19529f
C63 reset vdd_ext 4.48789f
C64 sar_comparator_input vdd_ext 1.06679f
C65 latch_sense_n_ext_uq1 vdd_ext 4.71191f
C66 decision_n decision_p 2.54301f
C67 tail_ext decision_p 0.48065f
C68 physical_preamp_p.latch_sense_p_ext row_drive 0.08419f
C69 row_dac_10b_0.vdd row_drive 1.11462f
C70 sar_comparator_input latch_sense_n_ext_uq1 0.04367f
C71 row_dac_10b_0.vss row_dac_10b_0.vdd 0.78467f
C72 shared_converter_mux_0.vss vdd_ext 0
C73 vss vss_escape 36.2394f
C74 vdd vss_escape 36.7f
C75 iso_tail_ext vss_escape 77.06784f
C76 latch_sense_p_ext vss_escape 47.08435f
C77 decision_p vss_escape 11.41912f
C78 tail_ext vss_escape 0.11841p
C79 latch_sense_n_ext_uq1 vss_escape 9.0153f
C80 vdd_ext vss_escape 0.26621p
C81 m4_51060_36440# vss_escape 0.13014f ; **FLOATING
C82 m4_45060_36440# vss_escape 0.10814f ; **FLOATING
C83 sar_readout_12b_0.vss vss_escape 1.33686f ; **FLOATING
C84 row_dac_10b_0.vss vss_escape 1.40333f ; **FLOATING
C85 row_dac_10b_0.vdd vss_escape 1.33457f ; **FLOATING
C86 sar_readout_12b_0.vdd vss_escape 1.77614f ; **FLOATING
C87 m1_68300_3080# vss_escape 7.89552f ; **FLOATING
C88 shared_converter_mux_0.vss vss_escape 1.39454f ; **FLOATING
C89 shared_converter_mux_0.mux_bus vss_escape 2.86922f ; **FLOATING
C90 shared_converter_mux_0.vdd vss_escape 0.95985f ; **FLOATING
C91 latch_sense_n_ext vss_escape 5.78341f
C92 physical_preamp_p.latch_sense_p_ext vss_escape 0.53398f
.ends
