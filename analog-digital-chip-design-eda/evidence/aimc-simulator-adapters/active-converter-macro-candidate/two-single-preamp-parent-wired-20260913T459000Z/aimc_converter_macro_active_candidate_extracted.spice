* NGSPICE file created from aimc_converter_macro_active_candidate_flat.ext - technology: sky130A

.subckt aimc_converter_macro_active_candidate_flat vss vdd row_drive sar_comparator_input
+ decision_p decision_n reset eval vss_escape latch_sense_n_ext iso_tail_ext tail_ext
+ vdd_ext
X0 vdd_ext decision_p decision_n vdd_ext sky130_fd_pr__pfet_01v8 ad=3.12 pd=7.6 as=3.36 ps=8 w=1.2 l=0.6
X1 tail_ext eval vss_escape vss_escape sky130_fd_pr__nfet_01v8 ad=16.2 pd=17.4 as=16.2 ps=17.4 w=6 l=0.6
X2 physical_preamp_n.drain sar_comparator_input row_drive vss_escape sky130_fd_pr__nfet_01v8 ad=3.36 pd=8 as=3.12 ps=7.6 w=1.2 l=0.6
X3 decision_p row_drive tail_ext vss_escape sky130_fd_pr__nfet_01v8 ad=3.36 pd=8 as=3.12 ps=7.6 w=1.2 l=0.6
X4 vdd_ext reset decision_n vdd_ext sky130_fd_pr__pfet_01v8 ad=3.12 pd=7.6 as=3.36 ps=8 w=1.2 l=0.6
X5 tail_ext latch_sense_n_ext decision_n vss_escape sky130_fd_pr__nfet_01v8 ad=3.12 pd=7.6 as=3.36 ps=8 w=1.2 l=0.6
X6 decision_p decision_n vdd_ext vdd_ext sky130_fd_pr__pfet_01v8 ad=3.36 pd=8 as=3.12 ps=7.6 w=1.2 l=0.6
X7 tail_ext decision_p decision_n vss_escape sky130_fd_pr__nfet_01v8 ad=3.12 pd=7.6 as=3.36 ps=8 w=1.2 l=0.6
X8 row_drive row_drive iso_tail_ext vss_escape sky130_fd_pr__nfet_01v8 ad=3.36 pd=8 as=3.12 ps=7.6 w=1.2 l=0.6
X9 iso_tail_ext sar_comparator_input latch_sense_n_ext vss_escape sky130_fd_pr__nfet_01v8 ad=3.12 pd=7.6 as=3.36 ps=8 w=1.2 l=0.6
X10 decision_p reset vdd_ext vdd_ext sky130_fd_pr__pfet_01v8 ad=3.36 pd=8 as=3.12 ps=7.6 w=1.2 l=0.6
X11 physical_preamp_p.drain row_drive row_drive vss_escape sky130_fd_pr__nfet_01v8 ad=3.36 pd=8 as=3.12 ps=7.6 w=1.2 l=0.6
X12 decision_p decision_n tail_ext vss_escape sky130_fd_pr__nfet_01v8 ad=3.36 pd=8 as=3.12 ps=7.6 w=1.2 l=0.6
C0 decision_p reset 0.376f
C1 row_drive iso_tail_ext 2.52281f
C2 shared_converter_mux_0.mux_bus shared_converter_mux_0.vss 1.56188f
C3 row_drive row_dac_10b_0.vss 1.08123f
C4 latch_sense_n_ext vdd_ext 3.48444f
C5 shared_converter_mux_0.vdd vss 0.2816f
C6 vdd_ext vss 0.19458f
C7 decision_n latch_sense_n_ext 0.18428f
C8 physical_preamp_n.drain vdd_ext 0.01965f
C9 row_drive latch_sense_n_ext 0.62346f
C10 row_drive vss 0.73578f
C11 latch_sense_n_ext tail_ext 0.0334f
C12 row_drive physical_preamp_n.drain 0.07426f
C13 vdd_ext sar_comparator_input 1.59943f
C14 physical_preamp_p.drain vdd_ext 0.01028f
C15 decision_n sar_comparator_input 0.27273f
C16 decision_p vdd_ext 3.8282f
C17 row_drive sar_comparator_input 6.84282f
C18 latch_sense_n_ext iso_tail_ext 0.12577f
C19 tail_ext sar_comparator_input 0.21605f
C20 physical_preamp_p.drain row_drive 0.59566f
C21 decision_n decision_p 2.54301f
C22 row_drive decision_p 0.31086f
C23 decision_p tail_ext 0.48065f
C24 sar_readout_12b_0.vdd vdd_ext 1.39936f
C25 row_drive sar_readout_12b_0.vdd 0.58157f
C26 sar_readout_12b_0.vss vdd_ext 0.93663f
C27 latch_sense_n_ext vss 0.23329f
C28 eval vdd_ext 0
C29 row_dac_10b_0.vdd row_drive 1.11462f
C30 iso_tail_ext sar_comparator_input 0.16721f
C31 latch_sense_n_ext physical_preamp_n.drain 0.47125f
C32 row_drive sar_readout_12b_0.vss 0.29433f
C33 row_drive vdd 0.1964f
C34 shared_converter_mux_0.vdd shared_converter_mux_0.mux_bus 1.55306f
C35 vdd_ext shared_converter_mux_0.mux_bus 0.00217f
C36 vdd_ext shared_converter_mux_0.vss 0
C37 eval tail_ext 0.36751f
C38 row_drive shared_converter_mux_0.mux_bus 0.06281f
C39 row_drive shared_converter_mux_0.vss 0.00246f
C40 latch_sense_n_ext sar_comparator_input 0.43167f
C41 vdd_ext m1_68300_3080# 0.24419f
C42 vss sar_comparator_input 0.09437f
C43 sar_readout_12b_0.vdd iso_tail_ext 0.27521f
C44 physical_preamp_n.drain sar_comparator_input 0.04085f
C45 row_drive m1_68300_3080# 2.68328f
C46 sar_readout_12b_0.vss iso_tail_ext 0.60045f
C47 row_dac_10b_0.vdd row_dac_10b_0.vss 0.78467f
C48 vdd_ext reset 4.48789f
C49 decision_n reset 0.31048f
C50 tail_ext reset 0.17577f
C51 shared_converter_mux_0.mux_bus vss 0.03132f
C52 vdd_ext shared_converter_mux_0.vdd 0
C53 decision_n vdd_ext 3.9382f
C54 row_drive shared_converter_mux_0.vdd 0.00246f
C55 row_drive vdd_ext 7.65711f
C56 vdd_ext tail_ext 1.9856f
C57 sar_readout_12b_0.vss sar_readout_12b_0.vdd 0.49712f
C58 m1_68300_3080# sar_comparator_input 0.05195f
C59 decision_n tail_ext 0.48065f
C60 row_drive tail_ext 0.07814f
C61 vdd_ext iso_tail_ext 0.86179f
C62 vss vss_escape 36.1986f
C63 vdd vss_escape 36.7f
C64 iso_tail_ext vss_escape 20.9682f
C65 decision_p vss_escape 20.25958f
C66 tail_ext vss_escape 0.17114p
C67 vdd_ext vss_escape 0.25705p
C68 sar_readout_12b_0.vss vss_escape 1.33686f ; **FLOATING
C69 row_dac_10b_0.vss vss_escape 1.40333f ; **FLOATING
C70 row_dac_10b_0.vdd vss_escape 1.33457f ; **FLOATING
C71 sar_readout_12b_0.vdd vss_escape 1.77614f ; **FLOATING
C72 m1_68300_3080# vss_escape 7.89552f ; **FLOATING
C73 shared_converter_mux_0.vss vss_escape 1.39454f ; **FLOATING
C74 shared_converter_mux_0.mux_bus vss_escape 2.86922f ; **FLOATING
C75 shared_converter_mux_0.vdd vss_escape 0.95985f ; **FLOATING
C76 physical_preamp_n.drain vss_escape 16.19815f
C77 physical_preamp_p.drain vss_escape 0.3809f
.ends
