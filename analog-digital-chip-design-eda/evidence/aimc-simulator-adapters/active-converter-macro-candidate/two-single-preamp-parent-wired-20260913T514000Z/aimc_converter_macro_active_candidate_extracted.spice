* NGSPICE file created from aimc_converter_macro_active_candidate_flat.ext - technology: sky130A

.subckt aimc_converter_macro_active_candidate_flat vss vdd row_drive sar_comparator_input
+ decision_p decision_n reset eval vss_escape latch_sense_n_ext iso_tail_ext tail_ext
+ vdd_ext
X0 latch_sense_n_ext physical_preamp_n.sar_comparator_input row_drive vss_escape sky130_fd_pr__nfet_01v8 ad=3.36 pd=8 as=3.12 ps=7.6 w=1.2 l=0.6
X1 vdd_ext decision_p decision_n vdd_ext sky130_fd_pr__pfet_01v8 ad=3.12 pd=7.6 as=3.36 ps=8 w=1.2 l=0.6
X2 tail_ext eval vss_escape vss_escape sky130_fd_pr__nfet_01v8 ad=16.2 pd=17.4 as=16.2 ps=17.4 w=6 l=0.6
X3 decision_p row_drive tail_ext vss_escape sky130_fd_pr__nfet_01v8 ad=3.36 pd=8 as=3.12 ps=7.6 w=1.2 l=0.6
X4 vdd_ext reset decision_n vdd_ext sky130_fd_pr__pfet_01v8 ad=3.12 pd=7.6 as=3.36 ps=8 w=1.2 l=0.6
X5 tail_ext latch_sense_n_ext decision_n vss_escape sky130_fd_pr__nfet_01v8 ad=3.12 pd=7.6 as=3.36 ps=8 w=1.2 l=0.6
X6 decision_p decision_n vdd_ext vdd_ext sky130_fd_pr__pfet_01v8 ad=3.36 pd=8 as=3.12 ps=7.6 w=1.2 l=0.6
X7 tail_ext decision_p decision_n vss_escape sky130_fd_pr__nfet_01v8 ad=3.12 pd=7.6 as=3.36 ps=8 w=1.2 l=0.6
X8 row_drive row_drive iso_tail_ext vss_escape sky130_fd_pr__nfet_01v8 ad=3.36 pd=8 as=3.12 ps=7.6 w=1.2 l=0.6
X9 iso_tail_ext sar_comparator_input latch_sense_n_ext vss_escape sky130_fd_pr__nfet_01v8 ad=3.12 pd=7.6 as=3.36 ps=8 w=1.2 l=0.6
X10 row_drive row_drive row_drive vss_escape sky130_fd_pr__nfet_01v8 ad=3.12 pd=7.6 as=12.96 ps=31.2 w=1.2 l=0.6
X11 decision_p reset vdd_ext vdd_ext sky130_fd_pr__pfet_01v8 ad=3.36 pd=8 as=3.12 ps=7.6 w=1.2 l=0.6
X12 decision_p decision_n tail_ext vss_escape sky130_fd_pr__nfet_01v8 ad=3.36 pd=8 as=3.12 ps=7.6 w=1.2 l=0.6
C0 row_drive m4_32000_38940# 0.00354f
C1 m4_45060_36440# latch_sense_n_ext 0.00655f
C2 row_drive vss 0.51482f
C3 vdd_ext latch_sense_n_ext 4.55721f
C4 vdd_ext sar_readout_12b_0.vss 0.93663f
C5 decision_n tail_ext 0.48065f
C6 row_drive eval 0.19752f
C7 physical_preamp_n.sar_comparator_input vdd_ext 0.01545f
C8 row_drive sar_comparator_input 5.22878f
C9 decision_p tail_ext 0.48065f
C10 m4_32000_38940# latch_sense_n_ext 0.0096f
C11 vss latch_sense_n_ext 0.29037f
C12 row_drive reset 0.19529f
C13 vdd_ext tail_ext 1.9856f
C14 shared_converter_mux_0.mux_bus shared_converter_mux_0.vss 1.56188f
C15 sar_comparator_input latch_sense_n_ext 0.04367f
C16 vdd_ext m4_51060_36440# 0.01404f
C17 vdd_ext iso_tail_ext 0.86179f
C18 vdd_ext shared_converter_mux_0.vss 0
C19 vdd_ext m1_68300_3080# 0.24419f
C20 row_dac_10b_0.vss row_drive 1.08123f
C21 row_drive latch_sense_n_ext 1.6695f
C22 sar_readout_12b_0.vss row_drive 0.29433f
C23 physical_preamp_n.sar_comparator_input row_drive 0.49327f
C24 vdd_ext sar_readout_12b_0.vdd 1.39936f
C25 tail_ext eval 0.36751f
C26 sar_comparator_input iso_tail_ext 0.16721f
C27 physical_preamp_n.sar_comparator_input latch_sense_n_ext 0.2f
C28 row_dac_10b_0.vdd row_drive 1.11462f
C29 row_drive tail_ext 0.99589f
C30 reset tail_ext 0.17577f
C31 decision_p decision_n 2.54301f
C32 row_drive m4_51060_36440# 0.00179f
C33 row_drive iso_tail_ext 2.52654f
C34 row_drive shared_converter_mux_0.vss 0.00246f
C35 row_drive m1_68300_3080# 2.68328f
C36 vdd_ext decision_n 3.9382f
C37 row_dac_10b_0.vss row_dac_10b_0.vdd 0.78467f
C38 tail_ext latch_sense_n_ext 1.09601f
C39 row_drive sar_readout_12b_0.vdd 0.58157f
C40 m4_51060_36440# latch_sense_n_ext 0.00671f
C41 vdd_ext decision_p 3.8282f
C42 shared_converter_mux_0.vdd shared_converter_mux_0.mux_bus 1.55306f
C43 physical_preamp_n.sar_comparator_input m4_51060_36440# 0.12862f
C44 iso_tail_ext latch_sense_n_ext 0.12999f
C45 sar_readout_12b_0.vss iso_tail_ext 0.60045f
C46 vdd_ext shared_converter_mux_0.mux_bus 0.00217f
C47 vdd_ext m4_45060_36440# 0.01404f
C48 vdd_ext shared_converter_mux_0.vdd 0
C49 sar_readout_12b_0.vss sar_readout_12b_0.vdd 0.49712f
C50 vss shared_converter_mux_0.mux_bus 0.03132f
C51 shared_converter_mux_0.vdd vss 0.2816f
C52 row_drive vdd 0.1964f
C53 vdd_ext vss 0.19458f
C54 decision_n reset 0.31048f
C55 row_drive decision_p 0.37635f
C56 decision_p reset 0.376f
C57 vdd_ext eval 0
C58 vdd_ext sar_comparator_input 1.06679f
C59 row_drive shared_converter_mux_0.mux_bus 0.06281f
C60 row_drive m4_45060_36440# 0.13195f
C61 row_drive shared_converter_mux_0.vdd 0.00246f
C62 sar_readout_12b_0.vdd iso_tail_ext 0.27521f
C63 decision_n latch_sense_n_ext 0.37635f
C64 vdd_ext row_drive 9.23865f
C65 vdd_ext reset 4.48789f
C66 vss vss_escape 36.2394f
C67 vdd vss_escape 36.7f
C68 iso_tail_ext vss_escape 29.9835f
C69 decision_p vss_escape 25.09136f
C70 tail_ext vss_escape 0.21183p
C71 latch_sense_n_ext vss_escape 9.0153f
C72 vdd_ext vss_escape 0.26067p
C73 m4_51060_36440# vss_escape 0.11856f ; **FLOATING
C74 m4_45060_36440# vss_escape 0.10718f ; **FLOATING
C75 m4_32000_38940# vss_escape 0.1568f ; **FLOATING
C76 sar_readout_12b_0.vss vss_escape 1.33686f ; **FLOATING
C77 row_dac_10b_0.vss vss_escape 1.40333f ; **FLOATING
C78 row_dac_10b_0.vdd vss_escape 1.33457f ; **FLOATING
C79 sar_readout_12b_0.vdd vss_escape 1.77614f ; **FLOATING
C80 m1_68300_3080# vss_escape 7.89552f ; **FLOATING
C81 shared_converter_mux_0.vss vss_escape 1.39454f ; **FLOATING
C82 shared_converter_mux_0.mux_bus vss_escape 2.86922f ; **FLOATING
C83 shared_converter_mux_0.vdd vss_escape 0.95985f ; **FLOATING
.ends
