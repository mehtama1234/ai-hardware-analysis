* NGSPICE file created from aimc_converter_macro_active_candidate_flat.ext - technology: sky130A

.subckt aimc_converter_macro_active_candidate_flat vss vdd row_drive sar_comparator_input
+ decision_p decision_n reset eval vss_escape latch_sense_p_ext latch_sense_n_ext
+ iso_tail_ext tail_ext vdd_ext
X0 physical_preamp_n.latch_sense_n_ext physical_preamp_n.sar_comparator_input preamp_iso_tail_ext vss_escape sky130_fd_pr__nfet_01v8 ad=3.36 pd=8 as=3.12 ps=7.6 w=1.2 l=0.6
X1 vdd_ext decision_p decision_n vdd_ext sky130_fd_pr__pfet_01v8 ad=3.12 pd=7.6 as=3.36 ps=8 w=1.2 l=0.6
X2 tail_ext eval vss_escape vss_escape sky130_fd_pr__nfet_01v8 ad=16.2 pd=17.4 as=16.2 ps=17.4 w=6 l=0.6
X3 decision_p latch_sense_p_ext tail_ext vss_escape sky130_fd_pr__nfet_01v8 ad=3.36 pd=8 as=3.12 ps=7.6 w=1.2 l=0.6
X4 vdd_ext reset decision_n vdd_ext sky130_fd_pr__pfet_01v8 ad=3.12 pd=7.6 as=3.36 ps=8 w=1.2 l=0.6
X5 tail_ext latch_sense_n_ext decision_n vss_escape sky130_fd_pr__nfet_01v8 ad=3.12 pd=7.6 as=3.36 ps=8 w=1.2 l=0.6
X6 decision_p decision_n vdd_ext vdd_ext sky130_fd_pr__pfet_01v8 ad=3.36 pd=8 as=3.12 ps=7.6 w=1.2 l=0.6
X7 tail_ext decision_p decision_n vss_escape sky130_fd_pr__nfet_01v8 ad=3.12 pd=7.6 as=3.36 ps=8 w=1.2 l=0.6
X8 latch_sense_p_ext row_drive iso_tail_ext vss_escape sky130_fd_pr__nfet_01v8 ad=3.36 pd=8 as=3.12 ps=7.6 w=1.2 l=0.6
X9 iso_tail_ext sar_comparator_input latch_sense_n_ext vss_escape sky130_fd_pr__nfet_01v8 ad=3.12 pd=7.6 as=3.36 ps=8 w=1.2 l=0.6
X10 latch_sense_p_ext row_drive latch_sense_p_ext vss_escape sky130_fd_pr__nfet_01v8 ad=3.12 pd=7.6 as=9.84 ps=23.6 w=1.2 l=0.6
X11 decision_p reset vdd_ext vdd_ext sky130_fd_pr__pfet_01v8 ad=3.36 pd=8 as=3.12 ps=7.6 w=1.2 l=0.6
X12 decision_p decision_n tail_ext vss_escape sky130_fd_pr__nfet_01v8 ad=3.36 pd=8 as=3.12 ps=7.6 w=1.2 l=0.6
C0 m4_45060_36440# vdd_ext 0.01404f
C1 shared_converter_mux_0.vdd shared_converter_mux_0.mux_bus 1.55306f
C2 m4_51060_36440# vdd_ext 0.01404f
C3 vss row_drive 0.22445f
C4 preamp_iso_tail_ext_uq0 latch_sense_p_ext 0.31945f
C5 shared_converter_mux_0.vss row_drive 0.00246f
C6 latch_sense_n_ext tail_ext 0.0334f
C7 physical_preamp_n.sar_comparator_input row_drive 0.12269f
C8 preamp_iso_tail_ext_uq0 row_drive 0.39367f
C9 decision_p decision_n 2.54301f
C10 m1_68300_3080# vdd_ext 0.24419f
C11 physical_preamp_n.sar_comparator_input preamp_iso_tail_ext 0.12607f
C12 decision_p vdd_ext 3.8282f
C13 preamp_iso_tail_ext_uq0 preamp_iso_tail_ext 0.09981f
C14 iso_tail_ext latch_sense_p_ext 0.1295f
C15 physical_preamp_n.sar_comparator_input m4_51060_36440# 0.13059f
C16 m4_45060_36440# preamp_iso_tail_ext_uq0 0.04404f
C17 iso_tail_ext row_drive 2.39704f
C18 reset tail_ext 0.17577f
C19 eval vdd_ext 0
C20 latch_sense_p_ext tail_ext 0.99589f
C21 sar_comparator_input vdd_ext 1.06679f
C22 row_dac_10b_0.vdd row_drive 1.11462f
C23 iso_tail_ext sar_readout_12b_0.vdd 0.27521f
C24 decision_n vdd_ext 3.9382f
C25 shared_converter_mux_0.vdd row_drive 0.00246f
C26 preamp_iso_tail_ext physical_preamp_n.latch_sense_n_ext 0.07109f
C27 shared_converter_mux_0.mux_bus row_drive 0.06281f
C28 row_dac_10b_0.vdd row_dac_10b_0.vss 0.78467f
C29 vss vdd_ext 0.19458f
C30 shared_converter_mux_0.vss vdd_ext 0
C31 row_drive sar_readout_12b_0.vss 0.29433f
C32 physical_preamp_n.sar_comparator_input vdd_ext 0.01545f
C33 latch_sense_n_ext row_drive 0.58017f
C34 preamp_iso_tail_ext_uq0 vdd_ext 0.14466f
C35 decision_p tail_ext 0.48065f
C36 iso_tail_ext sar_comparator_input 0.16721f
C37 sar_readout_12b_0.vdd sar_readout_12b_0.vss 0.49712f
C38 vdd row_drive 0.1964f
C39 reset latch_sense_p_ext 0.19529f
C40 eval tail_ext 0.36751f
C41 iso_tail_ext vdd_ext 0.86179f
C42 row_drive latch_sense_p_ext 1.07128f
C43 physical_preamp_n.sar_comparator_input preamp_iso_tail_ext_uq0 0.25751f
C44 decision_n tail_ext 0.48065f
C45 tail_ext vdd_ext 1.9856f
C46 physical_preamp_n.latch_sense_n_ext vdd_ext 0.01216f
C47 shared_converter_mux_0.vdd vdd_ext 0
C48 m4_45060_36440# latch_sense_p_ext 0.00796f
C49 sar_readout_12b_0.vdd row_drive 0.58157f
C50 m4_45060_36440# row_drive 0.12597f
C51 shared_converter_mux_0.mux_bus vdd_ext 0.00217f
C52 sar_comparator_input latch_sense_n_ext 0.0435f
C53 row_drive row_dac_10b_0.vss 1.08123f
C54 decision_p reset 0.376f
C55 shared_converter_mux_0.vdd vss 0.2816f
C56 m4_51060_36440# preamp_iso_tail_ext 0.00179f
C57 decision_p latch_sense_p_ext 0.37635f
C58 latch_sense_n_ext decision_n 0.18428f
C59 physical_preamp_n.sar_comparator_input physical_preamp_n.latch_sense_n_ext 0.12076f
C60 sar_readout_12b_0.vss vdd_ext 0.93663f
C61 latch_sense_n_ext vdd_ext 3.56622f
C62 preamp_iso_tail_ext_uq0 physical_preamp_n.latch_sense_n_ext 0.08529f
C63 m1_68300_3080# row_drive 2.68328f
C64 vss shared_converter_mux_0.mux_bus 0.03132f
C65 shared_converter_mux_0.vss shared_converter_mux_0.mux_bus 1.56188f
C66 eval latch_sense_p_ext 0.19752f
C67 reset decision_n 0.31048f
C68 sar_comparator_input row_drive 5.22878f
C69 vss latch_sense_n_ext 0.23329f
C70 reset vdd_ext 4.48789f
C71 latch_sense_p_ext vdd_ext 5.38799f
C72 row_drive vdd_ext 3.83977f
C73 preamp_iso_tail_ext vdd_ext 0.0109f
C74 sar_readout_12b_0.vdd vdd_ext 1.39936f
C75 iso_tail_ext sar_readout_12b_0.vss 0.60045f
C76 iso_tail_ext latch_sense_n_ext 0.12884f
C77 vss latch_sense_p_ext 0.29037f
C78 vss vss_escape 36.2394f
C79 vdd vss_escape 36.7f
C80 iso_tail_ext vss_escape 77.06784f
C81 latch_sense_n_ext vss_escape 9.0153f
C82 decision_p vss_escape 10.68776f
C83 tail_ext vss_escape 0.10419p
C84 latch_sense_p_ext vss_escape 47.08435f
C85 vdd_ext vss_escape 0.25386p
C86 m4_51060_36440# vss_escape 0.13014f ; **FLOATING
C87 m4_45060_36440# vss_escape 0.09675f ; **FLOATING
C88 preamp_iso_tail_ext_uq0 vss_escape 16.8686f ; **FLOATING
C89 sar_readout_12b_0.vss vss_escape 1.33686f ; **FLOATING
C90 row_dac_10b_0.vss vss_escape 1.40333f ; **FLOATING
C91 row_dac_10b_0.vdd vss_escape 1.33457f ; **FLOATING
C92 sar_readout_12b_0.vdd vss_escape 1.77614f ; **FLOATING
C93 m1_68300_3080# vss_escape 7.89552f ; **FLOATING
C94 shared_converter_mux_0.vss vss_escape 1.39454f ; **FLOATING
C95 shared_converter_mux_0.mux_bus vss_escape 2.86922f ; **FLOATING
C96 shared_converter_mux_0.vdd vss_escape 0.95985f ; **FLOATING
C97 physical_preamp_n.latch_sense_n_ext vss_escape 5.82855f
C98 preamp_iso_tail_ext vss_escape 4.65433f
.ends
