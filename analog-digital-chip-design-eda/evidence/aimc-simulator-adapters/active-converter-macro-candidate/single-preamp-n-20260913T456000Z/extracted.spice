* NGSPICE file created from preamp_n_nfet.ext - technology: sky130A

.subckt preamp_n_nfet source drain gate body
X0 drain gate source body sky130_fd_pr__nfet_01v8 ad=3.36 pd=8 as=3.12 ps=7.6 w=1.2 l=0.6
C0 source drain 0.03982f
C1 source gate 0.02892f
C2 gate drain 0.02459f
C3 drain body 1.37396f
C4 source body 1.3736f
.ends
