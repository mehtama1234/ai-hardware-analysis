* NGSPICE file created from aimc_converter_macro_active_candidate_flat.ext - technology: sky130A

.subckt aimc_converter_macro_active_candidate_flat vss vdd row_drive sar_comparator_input
+ decision_p decision_n reset eval vss_escape latch_sense_p_ext latch_sense_n_ext
+ iso_tail_ext tail_ext vdd_ext preamp_iso_tail_ext
X0 physical_preamp_0.iso_tail physical_preamp_0.sense_n physical_preamp_0.iso_n vss_escape sky130_fd_pr__nfet_01v8 ad=3.12 pd=7.6 as=3.36 ps=8 w=1.2 l=0.6
X1 vdd_ext decision_p decision_n vdd_ext sky130_fd_pr__pfet_01v8 ad=3.12 pd=7.6 as=3.36 ps=8 w=1.2 l=0.6
X2 tail_ext eval vss_escape vss_escape sky130_fd_pr__nfet_01v8 ad=16.2 pd=17.4 as=16.2 ps=17.4 w=6 l=0.6
X3 physical_preamp_0.iso_p physical_preamp_0.sense_p physical_preamp_0.iso_tail vss_escape sky130_fd_pr__nfet_01v8 ad=3.36 pd=8 as=3.12 ps=7.6 w=1.2 l=0.6
X4 decision_p latch_sense_p_ext tail_ext vss_escape sky130_fd_pr__nfet_01v8 ad=3.36 pd=8 as=3.12 ps=7.6 w=1.2 l=0.6
X5 vdd_ext reset decision_n vdd_ext sky130_fd_pr__pfet_01v8 ad=3.12 pd=7.6 as=3.36 ps=8 w=1.2 l=0.6
X6 tail_ext latch_sense_n_ext decision_n vss_escape sky130_fd_pr__nfet_01v8 ad=3.12 pd=7.6 as=3.36 ps=8 w=1.2 l=0.6
X7 decision_p decision_n vdd_ext vdd_ext sky130_fd_pr__pfet_01v8 ad=3.36 pd=8 as=3.12 ps=7.6 w=1.2 l=0.6
X8 tail_ext decision_p decision_n vss_escape sky130_fd_pr__nfet_01v8 ad=3.12 pd=7.6 as=3.36 ps=8 w=1.2 l=0.6
X9 latch_sense_p_ext row_drive iso_tail_ext vss_escape sky130_fd_pr__nfet_01v8 ad=3.36 pd=8 as=3.12 ps=7.6 w=1.2 l=0.6
X10 iso_tail_ext sar_comparator_input latch_sense_n_ext vss_escape sky130_fd_pr__nfet_01v8 ad=3.12 pd=7.6 as=3.36 ps=8 w=1.2 l=0.6
X11 decision_p reset vdd_ext vdd_ext sky130_fd_pr__pfet_01v8 ad=3.36 pd=8 as=3.12 ps=7.6 w=1.2 l=0.6
X12 decision_p decision_n tail_ext vss_escape sky130_fd_pr__nfet_01v8 ad=3.36 pd=8 as=3.12 ps=7.6 w=1.2 l=0.6
C0 physical_preamp_0.sense_p sar_comparator_input 0.04049f
C1 latch_sense_n_ext decision_n 0.18428f
C2 vdd_ext sar_comparator_input 1.05718f
C3 shared_converter_mux_0.vdd vss 0.2816f
C4 physical_preamp_0.iso_n physical_preamp_0.iso_tail 0.05717f
C5 sar_readout_12b_0.vdd row_drive 0.57218f
C6 shared_converter_mux_0.mux_bus vss 0.03132f
C7 vdd_ext latch_sense_p_ext 3.43095f
C8 physical_preamp_0.iso_n physical_preamp_0.iso_p 0.00782f
C9 latch_sense_p_ext decision_p 0.18428f
C10 physical_preamp_0.iso_tail row_drive 0.02471f
C11 preamp_iso_tail_ext m1_69940_2940# 0.03103f
C12 vdd_ext decision_n 3.9382f
C13 physical_preamp_0.iso_p row_drive 0.00133f
C14 decision_n decision_p 2.54301f
C15 physical_preamp_0.iso_tail physical_preamp_0.iso_p 0.05749f
C16 vdd_ext physical_preamp_0.sense_n 0.0039f
C17 physical_preamp_0.sense_p m2_64900_1400# 0.03637f
C18 m2_64900_1400# vdd_ext 0.07266f
C19 iso_tail_ext latch_sense_n_ext 0.12577f
C20 row_dac_10b_0.vss row_drive 1.08123f
C21 vss row_drive 0.22445f
C22 vdd_ext shared_converter_mux_0.vss 0
C23 latch_sense_n_ext tail_ext 0.0334f
C24 vdd_ext iso_tail_ext 0.86179f
C25 physical_preamp_0.iso_n sar_comparator_input 0.0285f
C26 vdd_ext tail_ext 1.9856f
C27 decision_p tail_ext 0.48065f
C28 vdd_ext latch_sense_n_ext 3.48444f
C29 sar_comparator_input row_drive 5.23145f
C30 decision_n reset 0.31048f
C31 latch_sense_p_ext row_drive 0.24412f
C32 physical_preamp_0.iso_tail sar_comparator_input 0.03759f
C33 physical_preamp_0.iso_p sar_comparator_input 0.02717f
C34 shared_converter_mux_0.mux_bus shared_converter_mux_0.vss 1.56188f
C35 physical_preamp_0.sense_p vdd_ext 0.03284f
C36 physical_preamp_0.iso_n physical_preamp_0.sense_n 0.02157f
C37 vdd_ext decision_p 3.8282f
C38 sar_readout_12b_0.vss iso_tail_ext 0.60045f
C39 m2_64900_1400# physical_preamp_0.iso_n 0.41846f
C40 tail_ext eval 0.36751f
C41 physical_preamp_0.sense_n physical_preamp_0.iso_tail 0.11179f
C42 m2_64900_1400# row_drive 0.00382f
C43 m2_64900_1400# physical_preamp_0.iso_tail 0.34398f
C44 row_dac_10b_0.vdd row_drive 1.11462f
C45 m2_64900_1400# physical_preamp_0.iso_p 0.41846f
C46 vss latch_sense_p_ext 0.23329f
C47 shared_converter_mux_0.vdd vdd_ext 0
C48 vdd_ext eval 0
C49 shared_converter_mux_0.mux_bus vdd_ext 0.00217f
C50 sar_readout_12b_0.vdd iso_tail_ext 0.27521f
C51 shared_converter_mux_0.vss row_drive 0.00246f
C52 vdd_ext sar_readout_12b_0.vss 0.93663f
C53 iso_tail_ext row_drive 1.97962f
C54 reset tail_ext 0.17577f
C55 latch_sense_n_ext row_drive 0.20099f
C56 shared_converter_mux_0.mux_bus shared_converter_mux_0.vdd 1.55306f
C57 row_dac_10b_0.vdd row_dac_10b_0.vss 0.78467f
C58 vdd_ext reset 4.48789f
C59 physical_preamp_0.iso_n vdd_ext 0.0106f
C60 decision_p reset 0.376f
C61 vdd_ext sar_readout_12b_0.vdd 1.39936f
C62 physical_preamp_0.sense_p row_drive 0.08156f
C63 vdd row_drive 0.1964f
C64 vdd_ext row_drive 2.69688f
C65 physical_preamp_0.sense_n sar_comparator_input 0.07548f
C66 physical_preamp_0.sense_p physical_preamp_0.iso_tail 0.12292f
C67 physical_preamp_0.sense_p physical_preamp_0.iso_p 0.02157f
C68 vdd_ext physical_preamp_0.iso_tail 0.30577f
C69 vdd_ext physical_preamp_0.iso_p 0.02484f
C70 m2_64900_1400# sar_comparator_input 0.1759f
C71 vss latch_sense_n_ext 0.23329f
C72 shared_converter_mux_0.vdd row_drive 0.00246f
C73 shared_converter_mux_0.mux_bus row_drive 0.06281f
C74 sar_readout_12b_0.vss sar_readout_12b_0.vdd 0.49712f
C75 m2_64900_1400# physical_preamp_0.sense_n 0.03955f
C76 iso_tail_ext sar_comparator_input 0.16721f
C77 iso_tail_ext latch_sense_p_ext 0.12577f
C78 sar_readout_12b_0.vss row_drive 0.29422f
C79 vdd_ext vss 0.20794f
C80 latch_sense_p_ext tail_ext 0.0334f
C81 latch_sense_n_ext sar_comparator_input 0.04279f
C82 decision_n tail_ext 0.48065f
C83 preamp_iso_tail_ext vss_escape 0.18641f
C84 vss vss_escape 36.2292f
C85 vdd vss_escape 36.7f
C86 iso_tail_ext vss_escape 55.47765f
C87 latch_sense_n_ext vss_escape 8.9128f
C88 latch_sense_p_ext vss_escape 24.51655f
C89 decision_p vss_escape 7.45999f
C90 tail_ext vss_escape 81.67176f
C91 vdd_ext vss_escape 0.25961p
C92 m2_64900_1400# vss_escape 0.72762f ; **FLOATING
C93 sar_readout_12b_0.vss vss_escape 1.33686f ; **FLOATING
C94 row_dac_10b_0.vss vss_escape 1.40333f ; **FLOATING
C95 row_dac_10b_0.vdd vss_escape 1.33457f ; **FLOATING
C96 sar_readout_12b_0.vdd vss_escape 1.77614f ; **FLOATING
C97 m1_69940_2940# vss_escape 0.19727f ; **FLOATING
C98 shared_converter_mux_0.vss vss_escape 1.39454f ; **FLOATING
C99 shared_converter_mux_0.mux_bus vss_escape 2.86922f ; **FLOATING
C100 shared_converter_mux_0.vdd vss_escape 0.95985f ; **FLOATING
C101 physical_preamp_0.iso_n vss_escape 1.04634f
C102 physical_preamp_0.iso_p vss_escape 1.04634f
C103 physical_preamp_0.iso_tail vss_escape 4.2324f
.ends
