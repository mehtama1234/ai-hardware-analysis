* NGSPICE file created from aimc_converter_macro_active_candidate_flat.ext - technology: sky130A

.subckt aimc_converter_macro_active_candidate_flat vss vdd row_drive sar_comparator_input
+ decision_p decision_n reset eval vss_escape latch_sense_p_ext latch_sense_n_ext
+ iso_tail_ext tail_ext vdd_ext
X0 latch_sense_n_ext physical_preamp_n.sar_comparator_input physical_preamp_n.preamp_iso_tail_ext vss_escape sky130_fd_pr__nfet_01v8 ad=3.36 pd=8 as=3.12 ps=7.6 w=1.2 l=0.6
X1 vdd_ext decision_p decision_n vdd_ext sky130_fd_pr__pfet_01v8 ad=3.12 pd=7.6 as=3.36 ps=8 w=1.2 l=0.6
X2 tail_ext eval vss_escape vss_escape sky130_fd_pr__nfet_01v8 ad=16.2 pd=17.4 as=16.2 ps=17.4 w=6 l=0.6
X3 decision_p latch_sense_p_ext tail_ext vss_escape sky130_fd_pr__nfet_01v8 ad=3.36 pd=8 as=3.12 ps=7.6 w=1.2 l=0.6
X4 vdd_ext reset decision_n vdd_ext sky130_fd_pr__pfet_01v8 ad=3.12 pd=7.6 as=3.36 ps=8 w=1.2 l=0.6
X5 tail_ext latch_sense_n_ext decision_n vss_escape sky130_fd_pr__nfet_01v8 ad=3.12 pd=7.6 as=3.36 ps=8 w=1.2 l=0.6
X6 decision_p decision_n vdd_ext vdd_ext sky130_fd_pr__pfet_01v8 ad=3.36 pd=8 as=3.12 ps=7.6 w=1.2 l=0.6
X7 tail_ext decision_p decision_n vss_escape sky130_fd_pr__nfet_01v8 ad=3.12 pd=7.6 as=3.36 ps=8 w=1.2 l=0.6
X8 latch_sense_p_ext row_drive iso_tail_ext vss_escape sky130_fd_pr__nfet_01v8 ad=3.36 pd=8 as=3.12 ps=7.6 w=1.2 l=0.6
X9 iso_tail_ext sar_comparator_input latch_sense_n_ext vss_escape sky130_fd_pr__nfet_01v8 ad=3.12 pd=7.6 as=3.36 ps=8 w=1.2 l=0.6
X10 latch_sense_p_ext row_drive preamp_iso_tail_ext vss_escape sky130_fd_pr__nfet_01v8 ad=3.36 pd=8 as=3.12 ps=7.6 w=1.2 l=0.6
X11 decision_p reset vdd_ext vdd_ext sky130_fd_pr__pfet_01v8 ad=3.36 pd=8 as=3.12 ps=7.6 w=1.2 l=0.6
X12 decision_p decision_n tail_ext vss_escape sky130_fd_pr__nfet_01v8 ad=3.36 pd=8 as=3.12 ps=7.6 w=1.2 l=0.6
C0 vss vdd_ext 0.19458f
C1 shared_converter_mux_0.vss vdd_ext 0
C2 physical_preamp_n.sar_comparator_input vdd_ext 0.01545f
C3 row_drive sar_readout_12b_0.vss 0.29433f
C4 iso_tail_ext latch_sense_n_ext 0.12999f
C5 iso_tail_ext sar_comparator_input 0.16721f
C6 sar_readout_12b_0.vdd sar_readout_12b_0.vss 0.49712f
C7 vdd row_drive 0.1964f
C8 tail_ext latch_sense_p_ext 0.99589f
C9 iso_tail_ext vdd_ext 0.86179f
C10 physical_preamp_n.preamp_iso_tail_ext latch_sense_n_ext 0.08127f
C11 row_drive latch_sense_p_ext 1.07514f
C12 eval vdd_ext 0
C13 preamp_iso_tail_ext latch_sense_p_ext 0.09803f
C14 reset decision_n 0.31048f
C15 physical_preamp_n.preamp_iso_tail_ext vdd_ext 0.00647f
C16 shared_converter_mux_0.vdd vdd_ext 0
C17 preamp_iso_tail_ext row_drive 0.17564f
C18 m4_45060_36440# latch_sense_p_ext 0.00708f
C19 sar_readout_12b_0.vdd row_drive 0.58157f
C20 decision_n latch_sense_n_ext 0.37635f
C21 m4_45060_36440# row_drive 0.12399f
C22 shared_converter_mux_0.mux_bus vdd_ext 0.00217f
C23 row_drive row_dac_10b_0.vss 1.08123f
C24 m4_45060_36440# preamp_iso_tail_ext 0
C25 reset tail_ext 0.17577f
C26 shared_converter_mux_0.vdd vss 0.2816f
C27 reset latch_sense_p_ext 0.19529f
C28 decision_n decision_p 2.54301f
C29 physical_preamp_n.sar_comparator_input physical_preamp_n.preamp_iso_tail_ext 0.07425f
C30 sar_readout_12b_0.vss vdd_ext 0.93663f
C31 decision_n vdd_ext 3.9382f
C32 m1_68300_3080# row_drive 2.68328f
C33 vss shared_converter_mux_0.mux_bus 0.03132f
C34 latch_sense_n_ext tail_ext 1.09601f
C35 shared_converter_mux_0.vss shared_converter_mux_0.mux_bus 1.56188f
C36 latch_sense_n_ext latch_sense_p_ext 0.59927f
C37 latch_sense_n_ext row_drive 0.96066f
C38 tail_ext decision_p 0.48065f
C39 sar_comparator_input row_drive 5.22878f
C40 decision_p latch_sense_p_ext 0.37635f
C41 tail_ext vdd_ext 1.9856f
C42 latch_sense_p_ext vdd_ext 5.38463f
C43 preamp_iso_tail_ext latch_sense_n_ext 0.01143f
C44 row_drive vdd_ext 3.84052f
C45 m4_45060_36440# latch_sense_n_ext 0.00655f
C46 m4_51060_36440# latch_sense_n_ext 0.00671f
C47 preamp_iso_tail_ext vdd_ext 0.00299f
C48 sar_readout_12b_0.vdd vdd_ext 1.39936f
C49 iso_tail_ext sar_readout_12b_0.vss 0.60045f
C50 vss latch_sense_p_ext 0.29037f
C51 m4_45060_36440# vdd_ext 0.01404f
C52 shared_converter_mux_0.vdd shared_converter_mux_0.mux_bus 1.55306f
C53 m4_51060_36440# vdd_ext 0.01404f
C54 vss row_drive 0.22445f
C55 m4_32000_38940# latch_sense_p_ext 0.00354f
C56 shared_converter_mux_0.vss row_drive 0.00246f
C57 physical_preamp_n.sar_comparator_input row_drive 0.40205f
C58 reset decision_p 0.376f
C59 m1_68300_3080# vdd_ext 0.24419f
C60 reset vdd_ext 4.48789f
C61 sar_comparator_input latch_sense_n_ext 0.04367f
C62 iso_tail_ext latch_sense_p_ext 0.1295f
C63 physical_preamp_n.sar_comparator_input m4_51060_36440# 0.12862f
C64 iso_tail_ext row_drive 2.39704f
C65 tail_ext eval 0.36751f
C66 latch_sense_n_ext vdd_ext 4.55721f
C67 latch_sense_p_ext eval 0.19752f
C68 sar_comparator_input vdd_ext 1.06679f
C69 row_dac_10b_0.vdd row_drive 1.11462f
C70 iso_tail_ext sar_readout_12b_0.vdd 0.27521f
C71 decision_p vdd_ext 3.8282f
C72 physical_preamp_n.preamp_iso_tail_ext row_drive 0.10202f
C73 shared_converter_mux_0.vdd row_drive 0.00246f
C74 vss latch_sense_n_ext 0.29037f
C75 physical_preamp_n.sar_comparator_input latch_sense_n_ext 0.2f
C76 shared_converter_mux_0.mux_bus row_drive 0.06281f
C77 row_dac_10b_0.vdd row_dac_10b_0.vss 0.78467f
C78 m4_32000_38940# latch_sense_n_ext 0.0096f
C79 decision_n tail_ext 0.48065f
C80 m4_51060_36440# physical_preamp_n.preamp_iso_tail_ext 0.00179f
C81 vss vss_escape 36.2394f
C82 vdd vss_escape 36.7f
C83 iso_tail_ext vss_escape 78.6418f
C84 decision_p vss_escape 12.33166f
C85 tail_ext vss_escape 0.12251p
C86 latch_sense_n_ext vss_escape 9.0153f
C87 latch_sense_p_ext vss_escape 48.6583f
C88 vdd_ext vss_escape 0.26069p
C89 m4_51060_36440# vss_escape 0.11856f ; **FLOATING
C90 m4_45060_36440# vss_escape 0.10718f ; **FLOATING
C91 m4_32000_38940# vss_escape 0.1568f ; **FLOATING
C92 sar_readout_12b_0.vss vss_escape 1.33686f ; **FLOATING
C93 row_dac_10b_0.vss vss_escape 1.40333f ; **FLOATING
C94 row_dac_10b_0.vdd vss_escape 1.33457f ; **FLOATING
C95 sar_readout_12b_0.vdd vss_escape 1.77614f ; **FLOATING
C96 m1_68300_3080# vss_escape 7.89552f ; **FLOATING
C97 shared_converter_mux_0.vss vss_escape 1.39454f ; **FLOATING
C98 shared_converter_mux_0.mux_bus vss_escape 2.86922f ; **FLOATING
C99 shared_converter_mux_0.vdd vss_escape 0.95985f ; **FLOATING
C100 physical_preamp_n.preamp_iso_tail_ext vss_escape 4.37048f
C101 preamp_iso_tail_ext vss_escape 0.38054f
.ends
