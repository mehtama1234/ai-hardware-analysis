* NGSPICE file created from aimc_converter_macro_active_candidate_flat.ext - technology: sky130A

.subckt aimc_converter_macro_active_candidate_flat vss vdd row_drive decision_p decision_n
+ reset eval latch_sense_p_ext iso_tail_ext tail_ext vdd_active_ext vdd_ext latch_sense_n_ext_uq1
X0 row_drive converter_latch_0.sense_p converter_latch_0.iso_tail vss sky130_fd_pr__nfet_01v8 ad=3.36 pd=8 as=3.12 ps=7.6 w=1.2 l=0.6
X1 vss vss vss vss sky130_fd_pr__nfet_01v8 ad=3.12 pd=7.6 as=54.24 ps=88 w=1.2 l=0.6
X2 row_drive row_drive vss vss sky130_fd_pr__nfet_01v8 ad=3.36 pd=8 as=3.12 ps=7.6 w=1.2 l=0.6
X3 row_drive row_drive vss vss sky130_fd_pr__nfet_01v8 ad=3.36 pd=8 as=3.12 ps=7.6 w=1.2 l=0.6
X4 row_drive row_drive converter_latch_0.vdd_active converter_latch_0.vdd_active sky130_fd_pr__pfet_01v8 ad=3.36 pd=8 as=3.12 ps=7.6 w=1.2 l=0.6
X5 row_drive row_drive vss vss sky130_fd_pr__nfet_01v8 ad=3.36 pd=8 as=3.12 ps=7.6 w=1.2 l=0.6
X6 vss row_drive vss vss sky130_fd_pr__nfet_01v8 ad=1.56 pd=3.8 as=0 ps=0 w=1.2 l=0.2
X7 row_drive converter_latch_0.reset converter_latch_0.vdd converter_latch_0.vdd sky130_fd_pr__pfet_01v8 ad=3.36 pd=8 as=3.12 ps=7.6 w=1.2 l=0.6
X8 converter_latch_0.iso_tail converter_latch_0.sense_n row_drive vss sky130_fd_pr__nfet_01v8 ad=3.12 pd=7.6 as=3.36 ps=8 w=1.2 l=0.6
X9 row_drive row_drive vss vss sky130_fd_pr__nfet_01v8 ad=3.36 pd=8 as=3.12 ps=7.6 w=1.2 l=0.6
X10 row_drive row_drive converter_latch_0.vdd_active converter_latch_0.vdd_active sky130_fd_pr__pfet_01v8 ad=3.36 pd=8 as=3.12 ps=7.6 w=1.2 l=0.6
X11 physical_preamp_p.drain row_drive vss vss sky130_fd_pr__nfet_01v8 ad=3.36 pd=8 as=3.12 ps=7.6 w=1.2 l=0.6
X12 vss converter_latch_0.eval vss vss sky130_fd_pr__nfet_01v8 ad=15.6 pd=17.2 as=0 ps=0 w=6 l=0.6
X13 row_drive converter_latch_0.reset converter_latch_0.vdd converter_latch_0.vdd sky130_fd_pr__pfet_01v8 ad=3.36 pd=8 as=3.12 ps=7.6 w=1.2 l=0.6
.ends
