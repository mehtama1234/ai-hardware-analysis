* NGSPICE file created from aimc_converter_macro_active_candidate_flat.ext - technology: sky130A

.subckt aimc_converter_macro_active_candidate_flat vss vdd row_drive decision_p decision_n
+ reset eval latch_sense_p_ext iso_tail_ext tail_ext vdd_active_ext vdd_ext latch_sense_n_ext_uq1
X0 row_drive converter_latch_0.sense_p converter_latch_0.iso_tail vss sky130_fd_pr__nfet_01v8 ad=3.36 pd=8 as=3.12 ps=7.6 w=1.2 l=0.6
X1 vss vss vss vss sky130_fd_pr__nfet_01v8 ad=3.12 pd=7.6 as=54.24 ps=88 w=1.2 l=0.6
X2 row_drive row_drive vss vss sky130_fd_pr__nfet_01v8 ad=3.36 pd=8 as=3.12 ps=7.6 w=1.2 l=0.6
X3 row_drive row_drive vss vss sky130_fd_pr__nfet_01v8 ad=3.36 pd=8 as=3.12 ps=7.6 w=1.2 l=0.6
X4 row_drive row_drive converter_latch_0.vdd_active converter_latch_0.vdd_active sky130_fd_pr__pfet_01v8 ad=3.36 pd=8 as=3.12 ps=7.6 w=1.2 l=0.6
X5 row_drive row_drive vss vss sky130_fd_pr__nfet_01v8 ad=3.36 pd=8 as=3.12 ps=7.6 w=1.2 l=0.6
X6 vss row_drive vss vss sky130_fd_pr__nfet_01v8 ad=1.56 pd=3.8 as=0 ps=0 w=1.2 l=0.2
X7 row_drive converter_latch_0.reset converter_latch_0.vdd converter_latch_0.vdd sky130_fd_pr__pfet_01v8 ad=3.36 pd=8 as=3.12 ps=7.6 w=1.2 l=0.6
X8 converter_latch_0.iso_tail converter_latch_0.sense_n row_drive vss sky130_fd_pr__nfet_01v8 ad=3.12 pd=7.6 as=3.36 ps=8 w=1.2 l=0.6
X9 row_drive row_drive vss vss sky130_fd_pr__nfet_01v8 ad=3.36 pd=8 as=3.12 ps=7.6 w=1.2 l=0.6
X10 row_drive row_drive converter_latch_0.vdd_active converter_latch_0.vdd_active sky130_fd_pr__pfet_01v8 ad=3.36 pd=8 as=3.12 ps=7.6 w=1.2 l=0.6
X11 physical_preamp_p.drain row_drive vss vss sky130_fd_pr__nfet_01v8 ad=3.36 pd=8 as=3.12 ps=7.6 w=1.2 l=0.6
X12 vss converter_latch_0.eval vss vss sky130_fd_pr__nfet_01v8 ad=15.6 pd=17.2 as=0 ps=0 w=6 l=0.6
X13 row_drive converter_latch_0.reset converter_latch_0.vdd converter_latch_0.vdd sky130_fd_pr__pfet_01v8 ad=3.36 pd=8 as=3.12 ps=7.6 w=1.2 l=0.6
C0 decision_p row_drive 0
C1 m1_21000_12500# converter_latch_0.sense_p 0.04904f
C2 sar_readout_12b_0.vss sar_readout_12b_0.vdd 0.53484f
C3 row_drive m1_68300_3080# 2.92746f
C4 converter_latch_0.vdd row_drive 5.44368f
C5 shared_converter_mux_0.mux_bus row_drive 0.06497f
C6 row_drive row_dac_10b_0.vdd 1.11462f
C7 iso_tail_ext row_drive 0.00405f
C8 converter_latch_0.sense_p converter_latch_0.iso_tail 0.12292f
C9 latch_sense_n_ext_uq1 converter_latch_0.reset 0
C10 m1_23440_12500# converter_latch_0.sense_n 0.04904f
C11 m1_23440_12500# converter_latch_0.iso_tail 0.00302f
C12 reset row_drive 0
C13 row_drive shared_converter_mux_0.vss 0.00313f
C14 shared_converter_mux_0.mux_bus shared_converter_mux_0.vss 1.56188f
C15 m1_21000_12500# row_drive 0.05106f
C16 eval row_drive 0
C17 row_drive sar_readout_12b_0.vdd 1.99263f
C18 converter_latch_0.sense_n row_drive 0.05507f
C19 converter_latch_0.iso_tail row_drive 0.24926f
C20 converter_latch_0.eval row_drive 0.05833f
C21 converter_latch_0.vdd converter_latch_0.reset 3.99047f
C22 converter_latch_0.reset row_drive 1.06081f
C23 vdd row_drive 0.1964f
C24 converter_latch_0.vdd_active row_drive 10.8826f
C25 m1_21000_12500# converter_latch_0.iso_tail 0.00302f
C26 converter_latch_0.vdd latch_sense_n_ext_uq1 0.00763f
C27 latch_sense_n_ext_uq1 row_drive 0.08492f
C28 row_drive sar_readout_12b_0.vss 1.3915f
C29 row_dac_10b_0.vss row_drive 1.08123f
C30 row_dac_10b_0.vss row_dac_10b_0.vdd 0.78467f
C31 converter_latch_0.sense_n converter_latch_0.iso_tail 0.11179f
C32 converter_latch_0.sense_p row_drive 0.06485f
C33 latch_sense_p_ext row_drive 0.04377f
C34 m1_23440_12500# row_drive 0.0106f
C35 shared_converter_mux_0.vdd row_drive 0.00313f
C36 shared_converter_mux_0.vdd shared_converter_mux_0.mux_bus 1.55306f
C37 physical_preamp_p.drain row_drive 0.12988f
C38 iso_tail_ext vss 0.08121f
C39 latch_sense_n_ext_uq1 vss 0.03836f
C40 decision_n vss 5.66255f
C41 latch_sense_p_ext vss 0.06822f
C42 decision_p vss 0.87454f
C43 vdd_active_ext vss 0.87518f
C44 reset vss 0.87454f
C45 vdd_ext vss 0.87518f
C46 eval vss 0.87454f
C47 tail_ext vss 0.09106f
C48 vdd vss 36.7f
C49 sar_readout_12b_0.vss vss 1.38755f ; **FLOATING
C50 row_dac_10b_0.vss vss 1.40333f ; **FLOATING
C51 row_dac_10b_0.vdd vss 1.33457f ; **FLOATING
C52 sar_readout_12b_0.vdd vss 1.77614f ; **FLOATING
C53 m1_68300_3080# vss 7.94747f ; **FLOATING
C54 shared_converter_mux_0.vss vss 1.39454f ; **FLOATING
C55 shared_converter_mux_0.mux_bus vss 2.90054f ; **FLOATING
C56 shared_converter_mux_0.vdd vss 1.24145f ; **FLOATING
C57 m1_23440_12500# vss 0.33861f ; **FLOATING
C58 m1_21000_12500# vss 0.33861f ; **FLOATING
C59 physical_preamp_p.drain vss 0.52922f
C60 converter_latch_0.iso_tail vss 4.24257f
C61 converter_latch_0.vdd vss 31.6224f
C62 converter_latch_0.vdd_active vss 46.0102f
.ends
