* NGSPICE file created from aimc_converter_macro_active_candidate_flat.ext - technology: sky130A

.subckt aimc_converter_macro_active_candidate_flat vss vdd row_drive sar_comparator_input
+ decision_p decision_n reset eval vss_escape latch_sense_p_ext latch_sense_n_ext
+ iso_tail_ext tail_ext vdd_ext
X0 physical_preamp_n.latch_sense_n_ext physical_preamp_n.sar_comparator_input preamp_iso_tail_ext vss_escape sky130_fd_pr__nfet_01v8 ad=3.36 pd=8 as=3.12 ps=7.6 w=1.2 l=0.6
X1 vdd_ext decision_p decision_n vdd_ext sky130_fd_pr__pfet_01v8 ad=3.12 pd=7.6 as=3.36 ps=8 w=1.2 l=0.6
X2 tail_ext eval vss_escape vss_escape sky130_fd_pr__nfet_01v8 ad=16.2 pd=17.4 as=16.2 ps=17.4 w=6 l=0.6
X3 decision_p latch_sense_p_ext tail_ext vss_escape sky130_fd_pr__nfet_01v8 ad=3.36 pd=8 as=3.12 ps=7.6 w=1.2 l=0.6
X4 vdd_ext reset decision_n vdd_ext sky130_fd_pr__pfet_01v8 ad=3.12 pd=7.6 as=3.36 ps=8 w=1.2 l=0.6
X5 tail_ext latch_sense_n_ext decision_n vss_escape sky130_fd_pr__nfet_01v8 ad=3.12 pd=7.6 as=3.36 ps=8 w=1.2 l=0.6
X6 decision_p decision_n vdd_ext vdd_ext sky130_fd_pr__pfet_01v8 ad=3.36 pd=8 as=3.12 ps=7.6 w=1.2 l=0.6
X7 tail_ext decision_p decision_n vss_escape sky130_fd_pr__nfet_01v8 ad=3.12 pd=7.6 as=3.36 ps=8 w=1.2 l=0.6
X8 latch_sense_p_ext row_drive iso_tail_ext vss_escape sky130_fd_pr__nfet_01v8 ad=3.36 pd=8 as=3.12 ps=7.6 w=1.2 l=0.6
X9 iso_tail_ext sar_comparator_input latch_sense_n_ext vss_escape sky130_fd_pr__nfet_01v8 ad=3.12 pd=7.6 as=3.36 ps=8 w=1.2 l=0.6
X10 physical_preamp_p.latch_sense_p_ext row_drive preamp_iso_tail_ext vss_escape sky130_fd_pr__nfet_01v8 ad=3.36 pd=8 as=3.12 ps=7.6 w=1.2 l=0.6
X11 decision_p reset vdd_ext vdd_ext sky130_fd_pr__pfet_01v8 ad=3.36 pd=8 as=3.12 ps=7.6 w=1.2 l=0.6
X12 decision_p decision_n tail_ext vss_escape sky130_fd_pr__nfet_01v8 ad=3.36 pd=8 as=3.12 ps=7.6 w=1.2 l=0.6
C0 physical_preamp_n.sar_comparator_input m4_51060_36440# 0.13059f
C1 iso_tail_ext row_drive 2.39704f
C2 tail_ext latch_sense_p_ext 0.99589f
C3 decision_p reset 0.376f
C4 tail_ext vdd_ext 1.9856f
C5 sar_comparator_input vdd_ext 1.06679f
C6 sar_readout_12b_0.vdd row_drive 0.58157f
C7 shared_converter_mux_0.mux_bus shared_converter_mux_0.vss 1.56188f
C8 latch_sense_p_ext vdd_ext 4.11646f
C9 physical_preamp_p.latch_sense_p_ext row_drive 0.08419f
C10 preamp_iso_tail_ext physical_preamp_p.latch_sense_p_ext 0.09914f
C11 preamp_iso_tail_ext physical_preamp_n.latch_sense_n_ext 0.15763f
C12 shared_converter_mux_0.vdd row_drive 0.00246f
C13 vss latch_sense_p_ext 0.29037f
C14 vss vdd_ext 0.19458f
C15 shared_converter_mux_0.mux_bus vdd_ext 0.00217f
C16 row_drive row_dac_10b_0.vss 1.08123f
C17 physical_preamp_n.sar_comparator_input vdd_ext 0.01545f
C18 latch_sense_n_ext row_drive 0.58017f
C19 sar_readout_12b_0.vss vdd_ext 0.93663f
C20 decision_n reset 0.31048f
C21 iso_tail_ext sar_comparator_input 0.16721f
C22 vdd row_drive 0.1964f
C23 iso_tail_ext latch_sense_p_ext 0.1295f
C24 tail_ext reset 0.17577f
C25 shared_converter_mux_0.mux_bus vss 0.03132f
C26 iso_tail_ext vdd_ext 0.86179f
C27 row_dac_10b_0.vdd row_dac_10b_0.vss 0.78467f
C28 sar_readout_12b_0.vdd vdd_ext 1.39936f
C29 latch_sense_p_ext reset 0.19529f
C30 reset vdd_ext 4.48789f
C31 decision_n latch_sense_n_ext 0.18428f
C32 physical_preamp_p.latch_sense_p_ext vdd_ext 0.01185f
C33 physical_preamp_n.latch_sense_n_ext vdd_ext 0.01216f
C34 preamp_iso_tail_ext row_drive 0.526f
C35 m1_68300_3080# row_drive 2.68328f
C36 iso_tail_ext sar_readout_12b_0.vss 0.60045f
C37 latch_sense_n_ext tail_ext 0.0334f
C38 m4_45060_36440# row_drive 0.13059f
C39 shared_converter_mux_0.vdd vdd_ext 0
C40 sar_comparator_input latch_sense_n_ext 0.0435f
C41 row_drive row_dac_10b_0.vdd 1.11462f
C42 sar_readout_12b_0.vss sar_readout_12b_0.vdd 0.49712f
C43 m4_45060_36440# preamp_iso_tail_ext 0.04583f
C44 decision_n decision_p 2.54301f
C45 m4_51060_36440# preamp_iso_tail_ext 0.00179f
C46 physical_preamp_n.sar_comparator_input physical_preamp_n.latch_sense_n_ext 0.1174f
C47 latch_sense_n_ext vdd_ext 3.56622f
C48 shared_converter_mux_0.vss row_drive 0.00246f
C49 vss shared_converter_mux_0.vdd 0.2816f
C50 tail_ext decision_p 0.48065f
C51 shared_converter_mux_0.mux_bus shared_converter_mux_0.vdd 1.55306f
C52 iso_tail_ext sar_readout_12b_0.vdd 0.27521f
C53 tail_ext eval 0.36751f
C54 decision_p latch_sense_p_ext 0.37635f
C55 vss latch_sense_n_ext 0.23329f
C56 sar_comparator_input row_drive 5.22878f
C57 latch_sense_p_ext eval 0.19752f
C58 decision_p vdd_ext 3.8282f
C59 eval vdd_ext 0
C60 row_drive latch_sense_p_ext 0.70701f
C61 row_drive vdd_ext 3.84053f
C62 preamp_iso_tail_ext vdd_ext 0.16645f
C63 m1_68300_3080# vdd_ext 0.24419f
C64 iso_tail_ext latch_sense_n_ext 0.12884f
C65 m4_45060_36440# vdd_ext 0.01404f
C66 m4_51060_36440# vdd_ext 0.01404f
C67 decision_n tail_ext 0.48065f
C68 vss row_drive 0.22445f
C69 shared_converter_mux_0.mux_bus row_drive 0.06281f
C70 physical_preamp_n.sar_comparator_input row_drive 0.12269f
C71 sar_readout_12b_0.vss row_drive 0.29433f
C72 shared_converter_mux_0.vss vdd_ext 0
C73 physical_preamp_n.sar_comparator_input preamp_iso_tail_ext 0.38422f
C74 decision_n vdd_ext 3.9382f
C75 vss vss_escape 36.2394f
C76 vdd vss_escape 36.7f
C77 iso_tail_ext vss_escape 77.06784f
C78 latch_sense_n_ext vss_escape 9.0153f
C79 latch_sense_p_ext vss_escape 47.08435f
C80 decision_p vss_escape 9.14438f
C81 tail_ext vss_escape 93.38767f
C82 vdd_ext vss_escape 0.25711p
C83 m4_51060_36440# vss_escape 0.13014f ; **FLOATING
C84 m4_45060_36440# vss_escape 0.10814f ; **FLOATING
C85 sar_readout_12b_0.vss vss_escape 1.33686f ; **FLOATING
C86 row_dac_10b_0.vss vss_escape 1.40333f ; **FLOATING
C87 row_dac_10b_0.vdd vss_escape 1.33457f ; **FLOATING
C88 sar_readout_12b_0.vdd vss_escape 1.77614f ; **FLOATING
C89 m1_68300_3080# vss_escape 7.89552f ; **FLOATING
C90 shared_converter_mux_0.vss vss_escape 1.39454f ; **FLOATING
C91 shared_converter_mux_0.mux_bus vss_escape 2.86922f ; **FLOATING
C92 shared_converter_mux_0.vdd vss_escape 0.95985f ; **FLOATING
C93 physical_preamp_n.latch_sense_n_ext vss_escape 5.78341f
C94 physical_preamp_p.latch_sense_p_ext vss_escape 0.53398f
C95 preamp_iso_tail_ext vss_escape 22.12867f
.ends
