*. Intended extracted preamp topology.
.subckt preamp_port_candidate preamp_iso_tail_ext latch_sense_p_ext latch_sense_n_ext row_drive sar_comparator_input vss_escape
Xpreamp_p latch_sense_p_ext row_drive preamp_iso_tail_ext vss_escape sky130_fd_pr__nfet_01v8 w=1.2 l=0.6
Xpreamp_n latch_sense_n_ext sar_comparator_input preamp_iso_tail_ext vss_escape sky130_fd_pr__nfet_01v8 w=1.2 l=0.6
.ends preamp_port_candidate
