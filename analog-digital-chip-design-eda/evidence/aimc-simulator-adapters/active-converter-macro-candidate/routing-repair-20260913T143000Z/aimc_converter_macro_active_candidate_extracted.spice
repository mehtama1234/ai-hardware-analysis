* NGSPICE file created from aimc_converter_macro_active_candidate_flat.ext - technology: sky130A

.subckt aimc_converter_macro_active_candidate_flat vss vdd decision_p decision_n reset
+ eval vss_escape latch_sense_p_ext latch_sense_n_ext iso_tail_ext tail_ext vdd_ext
X0 vdd_ext physical_preamp_0.sense_n physical_preamp_0.iso_n vss_escape sky130_fd_pr__nfet_01v8 ad=3.12 pd=7.6 as=3.36 ps=8 w=1.2 l=0.6
X1 vdd_ext decision_p decision_n vdd_ext sky130_fd_pr__pfet_01v8 ad=3.12 pd=7.6 as=3.36 ps=8 w=1.2 l=0.6
X2 tail_ext eval vss_escape vss_escape sky130_fd_pr__nfet_01v8 ad=16.2 pd=17.4 as=16.2 ps=17.4 w=6 l=0.6
X3 physical_preamp_0.iso_p physical_preamp_0.sense_p vdd_ext vss_escape sky130_fd_pr__nfet_01v8 ad=3.36 pd=8 as=3.12 ps=7.6 w=1.2 l=0.6
X4 decision_p latch_sense_p_ext tail_ext vss_escape sky130_fd_pr__nfet_01v8 ad=3.36 pd=8 as=3.12 ps=7.6 w=1.2 l=0.6
X5 vdd_ext reset decision_n vdd_ext sky130_fd_pr__pfet_01v8 ad=3.12 pd=7.6 as=3.36 ps=8 w=1.2 l=0.6
X6 tail_ext latch_sense_n_ext decision_n vss_escape sky130_fd_pr__nfet_01v8 ad=3.12 pd=7.6 as=3.36 ps=8 w=1.2 l=0.6
X7 decision_p decision_n vdd_ext vdd_ext sky130_fd_pr__pfet_01v8 ad=3.36 pd=8 as=3.12 ps=7.6 w=1.2 l=0.6
X8 tail_ext decision_p decision_n vss_escape sky130_fd_pr__nfet_01v8 ad=3.12 pd=7.6 as=3.36 ps=8 w=1.2 l=0.6
X9 latch_sense_p_ext vdd_ext iso_tail_ext vss_escape sky130_fd_pr__nfet_01v8 ad=3.36 pd=8 as=3.12 ps=7.6 w=1.2 l=0.6
X10 iso_tail_ext vdd_ext latch_sense_n_ext vss_escape sky130_fd_pr__nfet_01v8 ad=3.12 pd=7.6 as=3.36 ps=8 w=1.2 l=0.6
X11 decision_p reset vdd_ext vdd_ext sky130_fd_pr__pfet_01v8 ad=3.36 pd=8 as=3.12 ps=7.6 w=1.2 l=0.6
X12 decision_p decision_n tail_ext vss_escape sky130_fd_pr__nfet_01v8 ad=3.36 pd=8 as=3.12 ps=7.6 w=1.2 l=0.6
C0 physical_preamp_0.sense_p m3_42000_3080# 0
C1 decision_p latch_sense_p_ext 0.18428f
C2 vdd_ext tail_ext 1.9856f
C3 vdd_ext physical_preamp_0.iso_p 0.57841f
C4 sar_readout_12b_0.vdd iso_tail_ext 0.27521f
C5 decision_n latch_sense_n_ext 0.18428f
C6 latch_sense_p_ext iso_tail_ext 0.12577f
C7 decision_p reset 0.376f
C8 decision_n reset 0.31048f
C9 latch_sense_p_ext vss 0.23329f
C10 vdd_ext physical_preamp_0.iso_n 0.54343f
C11 vdd_ext physical_preamp_0.sense_n 0.35257f
C12 iso_tail_ext latch_sense_n_ext 0.12577f
C13 sar_readout_12b_0.vss iso_tail_ext 0.60045f
C14 decision_p vdd_ext 3.8282f
C15 decision_n vdd_ext 3.9382f
C16 physical_preamp_0.sense_n li_67560_2680# 0.10518f
C17 sar_readout_12b_0.vss sar_readout_12b_0.vdd 0.49712f
C18 vdd_ext eval 0
C19 vss latch_sense_n_ext 0.23329f
C20 vdd_ext m3_42000_3080# 3.25894f
C21 physical_preamp_0.sense_p vdd_ext 0.42393f
C22 m3_42000_3080# li_67560_2680# 0.03667f
C23 physical_preamp_0.iso_p physical_preamp_0.iso_n 0.00782f
C24 vdd_ext iso_tail_ext 3.42605f
C25 shared_converter_mux_0.mux_bus vss 0.03132f
C26 sar_readout_12b_0.vdd vdd_ext 1.97959f
C27 decision_p tail_ext 0.48065f
C28 decision_n tail_ext 0.48065f
C29 eval tail_ext 0.36751f
C30 latch_sense_p_ext vdd_ext 4.05235f
C31 vdd_ext vss 0.43806f
C32 m3_42000_3080# physical_preamp_0.iso_p 0
C33 physical_preamp_0.sense_p physical_preamp_0.iso_p 0.00681f
C34 shared_converter_mux_0.vdd vss 0.2816f
C35 row_dac_10b_0.vss row_dac_10b_0.vdd 0.78467f
C36 row_dac_10b_0.vss vdd_ext 1.08123f
C37 vdd_ext latch_sense_n_ext 4.10469f
C38 sar_readout_12b_0.vss vdd_ext 1.23096f
C39 physical_preamp_0.sense_n physical_preamp_0.iso_n 0.02157f
C40 reset vdd_ext 4.48789f
C41 latch_sense_p_ext tail_ext 0.0334f
C42 shared_converter_mux_0.vss shared_converter_mux_0.mux_bus 1.56188f
C43 decision_n decision_p 2.54301f
C44 shared_converter_mux_0.mux_bus vdd_ext 0.06497f
C45 m3_42000_3080# physical_preamp_0.iso_n 0
C46 shared_converter_mux_0.vss vdd_ext 0.00313f
C47 m3_42000_3080# physical_preamp_0.sense_n 0
C48 row_dac_10b_0.vdd vdd_ext 1.11462f
C49 vdd_ext vdd 0.1964f
C50 shared_converter_mux_0.mux_bus shared_converter_mux_0.vdd 1.55306f
C51 tail_ext latch_sense_n_ext 0.0334f
C52 vdd_ext li_67560_2680# 0.50408f
C53 vdd_ext shared_converter_mux_0.vdd 0.00313f
C54 reset tail_ext 0.17577f
C55 vss vss_escape 36.2211f
C56 vdd vss_escape 36.7f
C57 iso_tail_ext vss_escape 0.19839p
C58 latch_sense_p_ext vss_escape 0.17742p
C59 decision_p vss_escape 7.38983f
C60 tail_ext vss_escape 81.08725f
C61 m3_42000_3080# vss_escape 7.59003f ; **FLOATING
C62 sar_readout_12b_0.vss vss_escape 1.33686f ; **FLOATING
C63 row_dac_10b_0.vss vss_escape 1.40333f ; **FLOATING
C64 row_dac_10b_0.vdd vss_escape 1.33457f ; **FLOATING
C65 sar_readout_12b_0.vdd vss_escape 1.77614f ; **FLOATING
C66 shared_converter_mux_0.vss vss_escape 1.39454f ; **FLOATING
C67 shared_converter_mux_0.mux_bus vss_escape 2.86922f ; **FLOATING
C68 shared_converter_mux_0.vdd vss_escape 0.95985f ; **FLOATING
C69 li_67560_2680# vss_escape 1.56317f ; **FLOATING
C70 physical_preamp_0.iso_n vss_escape 1.18745f
C71 physical_preamp_0.iso_p vss_escape 1.00841f
.ends
