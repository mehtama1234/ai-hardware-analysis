* NGSPICE file created from preamp_port_candidate.ext - technology: sky130A

.subckt preamp_port_candidate preamp_iso_tail_ext latch_sense_p_ext latch_sense_n_ext
+ row_drive sar_comparator_input vss_escape
X0 preamp_iso_tail_ext a_3560_400# latch_sense_n_ext vss_escape sky130_fd_pr__nfet_01v8 ad=3.12 pd=7.6 as=3.36 ps=8 w=1.2 l=0.6
X1 latch_sense_p_ext a_1120_400# preamp_iso_tail_ext vss_escape sky130_fd_pr__nfet_01v8 ad=3.36 pd=8 as=3.12 ps=7.6 w=1.2 l=0.6
C0 preamp_iso_tail_ext a_3560_400# 0.11179f
C1 a_1120_400# row_drive 0.13241f
C2 preamp_iso_tail_ext a_1120_400# 0.12292f
C3 m2_900_1400# row_drive 0.01146f
C4 sar_comparator_input a_3560_400# 0.13241f
C5 preamp_iso_tail_ext m2_900_1400# 0.34398f
C6 a_1120_400# latch_sense_p_ext 0.02157f
C7 m2_900_1400# latch_sense_p_ext 0.41846f
C8 sar_comparator_input m2_900_1400# 0.01146f
C9 m2_900_1400# a_3560_400# 0.04273f
C10 m2_900_1400# a_1120_400# 0.04273f
C11 preamp_iso_tail_ext latch_sense_n_ext 0.05717f
C12 latch_sense_n_ext latch_sense_p_ext 0.00782f
C13 sar_comparator_input latch_sense_n_ext 0.0015f
C14 a_3560_400# latch_sense_n_ext 0.02157f
C15 preamp_iso_tail_ext row_drive 0.0015f
C16 m2_900_1400# latch_sense_n_ext 0.41846f
C17 row_drive latch_sense_p_ext 0.0015f
C18 preamp_iso_tail_ext latch_sense_p_ext 0.05749f
C19 sar_comparator_input preamp_iso_tail_ext 0.0015f
C20 sar_comparator_input vss_escape 0.367f
C21 row_drive vss_escape 0.367f
C22 latch_sense_n_ext vss_escape 1.13345f
C23 latch_sense_p_ext vss_escape 1.13345f
C24 preamp_iso_tail_ext vss_escape 4.40805f
C25 m2_900_1400# vss_escape 1.01648f ; **FLOATING
.ends
