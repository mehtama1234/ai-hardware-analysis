* NGSPICE file created from aimc_converter_macro_active_candidate_flat.ext - technology: sky130A

.subckt aimc_converter_macro_active_candidate_flat vss vdd row_drive sar_comparator_input
+ decision_p decision_n reset eval vss_escape latch_sense_p_ext latch_sense_n_ext
+ iso_tail_ext tail_ext vdd_ext
X0 physical_preamp_0.iso_tail physical_preamp_0.sense_n physical_preamp_0.iso_n vss_escape sky130_fd_pr__nfet_01v8 ad=3.12 pd=7.6 as=3.36 ps=8 w=1.2 l=0.6
X1 vdd_ext decision_p decision_n vdd_ext sky130_fd_pr__pfet_01v8 ad=3.12 pd=7.6 as=3.36 ps=8 w=1.2 l=0.6
X2 tail_ext eval vss_escape vss_escape sky130_fd_pr__nfet_01v8 ad=16.2 pd=17.4 as=16.2 ps=17.4 w=6 l=0.6
X3 physical_preamp_0.iso_p physical_preamp_0.sense_p physical_preamp_0.iso_tail vss_escape sky130_fd_pr__nfet_01v8 ad=3.36 pd=8 as=3.12 ps=7.6 w=1.2 l=0.6
X4 decision_p latch_sense_p_ext tail_ext vss_escape sky130_fd_pr__nfet_01v8 ad=3.36 pd=8 as=3.12 ps=7.6 w=1.2 l=0.6
X5 vdd_ext reset decision_n vdd_ext sky130_fd_pr__pfet_01v8 ad=3.12 pd=7.6 as=3.36 ps=8 w=1.2 l=0.6
X6 tail_ext latch_sense_n_ext decision_n vss_escape sky130_fd_pr__nfet_01v8 ad=3.12 pd=7.6 as=3.36 ps=8 w=1.2 l=0.6
X7 decision_p decision_n vdd_ext vdd_ext sky130_fd_pr__pfet_01v8 ad=3.36 pd=8 as=3.12 ps=7.6 w=1.2 l=0.6
X8 tail_ext decision_p decision_n vss_escape sky130_fd_pr__nfet_01v8 ad=3.12 pd=7.6 as=3.36 ps=8 w=1.2 l=0.6
X9 latch_sense_p_ext row_drive iso_tail_ext vss_escape sky130_fd_pr__nfet_01v8 ad=3.36 pd=8 as=3.12 ps=7.6 w=1.2 l=0.6
X10 iso_tail_ext sar_comparator_input latch_sense_n_ext vss_escape sky130_fd_pr__nfet_01v8 ad=3.12 pd=7.6 as=3.36 ps=8 w=1.2 l=0.6
X11 decision_p reset vdd_ext vdd_ext sky130_fd_pr__pfet_01v8 ad=3.36 pd=8 as=3.12 ps=7.6 w=1.2 l=0.6
X12 decision_p decision_n tail_ext vss_escape sky130_fd_pr__nfet_01v8 ad=3.36 pd=8 as=3.12 ps=7.6 w=1.2 l=0.6
C0 iso_tail_ext row_drive 1.97962f
C1 shared_converter_mux_0.vdd row_drive 0.00246f
C2 physical_preamp_0.iso_n physical_preamp_0.iso_tail 0.05717f
C3 physical_preamp_0.iso_n physical_preamp_0.iso_p 0.00782f
C4 vss latch_sense_n_ext 0.23329f
C5 sar_comparator_input latch_sense_n_ext 0.04279f
C6 row_drive latch_sense_n_ext 0.20099f
C7 tail_ext decision_n 0.48065f
C8 physical_preamp_0.iso_tail physical_preamp_0.iso_p 0.05749f
C9 tail_ext reset 0.17577f
C10 physical_preamp_0.sense_p sar_comparator_input 0.04049f
C11 tail_ext latch_sense_n_ext 0.0334f
C12 vdd_ext vss 0.21361f
C13 shared_converter_mux_0.vss row_drive 0.00246f
C14 vdd_ext sar_comparator_input 1.05718f
C15 sar_readout_12b_0.vdd row_drive 0.57218f
C16 physical_preamp_0.sense_p row_drive 0.08156f
C17 vdd_ext row_drive 2.69688f
C18 vdd_ext physical_preamp_0.sense_n 0.0039f
C19 shared_converter_mux_0.mux_bus vss 0.03132f
C20 vss latch_sense_p_ext 0.23329f
C21 tail_ext decision_p 0.48065f
C22 physical_preamp_0.iso_n sar_comparator_input 0.0285f
C23 reset decision_n 0.31048f
C24 eval vdd_ext 0
C25 latch_sense_n_ext decision_n 0.18428f
C26 physical_preamp_0.sense_p m2_64900_1400# 0.03637f
C27 tail_ext vdd_ext 1.9856f
C28 iso_tail_ext latch_sense_n_ext 0.12577f
C29 shared_converter_mux_0.mux_bus row_drive 0.06281f
C30 row_drive latch_sense_p_ext 0.24412f
C31 vdd_ext m2_64900_1400# 0.07266f
C32 sar_readout_12b_0.vss row_drive 0.29422f
C33 physical_preamp_0.iso_tail sar_comparator_input 0.03759f
C34 physical_preamp_0.iso_n physical_preamp_0.sense_n 0.02157f
C35 physical_preamp_0.iso_p sar_comparator_input 0.02717f
C36 row_drive vdd 0.1964f
C37 physical_preamp_0.iso_tail row_drive 0.02471f
C38 physical_preamp_0.iso_p row_drive 0.00133f
C39 decision_n decision_p 2.54301f
C40 tail_ext latch_sense_p_ext 0.0334f
C41 physical_preamp_0.iso_n m2_64900_1400# 0.41846f
C42 physical_preamp_0.sense_n physical_preamp_0.iso_tail 0.11179f
C43 sar_readout_12b_0.vdd iso_tail_ext 0.27521f
C44 vdd_ext decision_n 3.9382f
C45 vdd_ext iso_tail_ext 0.86179f
C46 vdd_ext shared_converter_mux_0.vdd 0
C47 reset decision_p 0.376f
C48 physical_preamp_0.iso_tail m2_64900_1400# 0.34398f
C49 physical_preamp_0.iso_p m2_64900_1400# 0.41846f
C50 reset vdd_ext 4.48789f
C51 vdd_ext latch_sense_n_ext 3.48444f
C52 iso_tail_ext latch_sense_p_ext 0.12577f
C53 shared_converter_mux_0.mux_bus shared_converter_mux_0.vdd 1.55306f
C54 sar_readout_12b_0.vss iso_tail_ext 0.60045f
C55 vss row_drive 0.22445f
C56 shared_converter_mux_0.vss vdd_ext 0
C57 vdd_ext decision_p 3.8282f
C58 row_drive sar_comparator_input 5.23145f
C59 sar_readout_12b_0.vdd vdd_ext 1.39936f
C60 physical_preamp_0.sense_p vdd_ext 0.03284f
C61 physical_preamp_0.sense_n sar_comparator_input 0.07548f
C62 row_dac_10b_0.vss row_drive 1.08123f
C63 shared_converter_mux_0.vss shared_converter_mux_0.mux_bus 1.56188f
C64 latch_sense_p_ext decision_p 0.18428f
C65 m2_64900_1400# sar_comparator_input 0.1759f
C66 physical_preamp_0.iso_n vdd_ext 0.0106f
C67 sar_readout_12b_0.vdd sar_readout_12b_0.vss 0.49712f
C68 shared_converter_mux_0.mux_bus vdd_ext 0.00217f
C69 vdd_ext latch_sense_p_ext 3.43095f
C70 row_drive m2_64900_1400# 0.00382f
C71 vdd_ext sar_readout_12b_0.vss 0.93663f
C72 physical_preamp_0.sense_p physical_preamp_0.iso_tail 0.12292f
C73 physical_preamp_0.sense_n m2_64900_1400# 0.03955f
C74 physical_preamp_0.sense_p physical_preamp_0.iso_p 0.02157f
C75 vdd_ext physical_preamp_0.iso_tail 0.30357f
C76 row_dac_10b_0.vdd row_drive 1.11462f
C77 vdd_ext physical_preamp_0.iso_p 0.02484f
C78 tail_ext eval 0.36751f
C79 shared_converter_mux_0.vdd vss 0.2816f
C80 iso_tail_ext sar_comparator_input 0.16721f
C81 row_dac_10b_0.vss row_dac_10b_0.vdd 0.78467f
C82 vss vss_escape 36.2211f
C83 vdd vss_escape 36.7f
C84 iso_tail_ext vss_escape 55.47765f
C85 latch_sense_n_ext vss_escape 8.9128f
C86 latch_sense_p_ext vss_escape 24.51655f
C87 decision_p vss_escape 7.45999f
C88 tail_ext vss_escape 81.67176f
C89 vdd_ext vss_escape 0.25966p
C90 m2_64900_1400# vss_escape 0.72762f ; **FLOATING
C91 sar_readout_12b_0.vss vss_escape 1.33686f ; **FLOATING
C92 row_dac_10b_0.vss vss_escape 1.40333f ; **FLOATING
C93 row_dac_10b_0.vdd vss_escape 1.33457f ; **FLOATING
C94 sar_readout_12b_0.vdd vss_escape 1.77614f ; **FLOATING
C95 shared_converter_mux_0.vss vss_escape 1.39454f ; **FLOATING
C96 shared_converter_mux_0.mux_bus vss_escape 2.86922f ; **FLOATING
C97 shared_converter_mux_0.vdd vss_escape 0.95985f ; **FLOATING
C98 physical_preamp_0.iso_n vss_escape 1.04634f
C99 physical_preamp_0.iso_p vss_escape 1.04634f
C100 physical_preamp_0.iso_tail vss_escape 4.23749f
.ends
