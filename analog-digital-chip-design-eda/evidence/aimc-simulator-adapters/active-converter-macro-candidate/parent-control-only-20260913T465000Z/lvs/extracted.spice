* NGSPICE file created from aimc_converter_macro_active_candidate_flat.ext - technology: sky130A

.subckt aimc_converter_macro_active_candidate_flat vss vdd row_drive sar_comparator_input
+ decision_p decision_n reset eval vss_escape latch_sense_p_ext latch_sense_n_ext
+ iso_tail_ext tail_ext vdd_ext
X0 vdd_ext decision_p decision_n vdd_ext sky130_fd_pr__pfet_01v8 ad=3.12 pd=7.6 as=3.36 ps=8 w=1.2 l=0.6
X1 tail_ext eval vss_escape vss_escape sky130_fd_pr__nfet_01v8 ad=16.2 pd=17.4 as=16.2 ps=17.4 w=6 l=0.6
X2 decision_p latch_sense_p_ext tail_ext vss_escape sky130_fd_pr__nfet_01v8 ad=3.36 pd=8 as=3.12 ps=7.6 w=1.2 l=0.6
X3 vdd_ext reset decision_n vdd_ext sky130_fd_pr__pfet_01v8 ad=3.12 pd=7.6 as=3.36 ps=8 w=1.2 l=0.6
X4 tail_ext latch_sense_n_ext decision_n vss_escape sky130_fd_pr__nfet_01v8 ad=3.12 pd=7.6 as=3.36 ps=8 w=1.2 l=0.6
X5 decision_p decision_n vdd_ext vdd_ext sky130_fd_pr__pfet_01v8 ad=3.36 pd=8 as=3.12 ps=7.6 w=1.2 l=0.6
X6 tail_ext decision_p decision_n vss_escape sky130_fd_pr__nfet_01v8 ad=3.12 pd=7.6 as=3.36 ps=8 w=1.2 l=0.6
X7 latch_sense_p_ext row_drive iso_tail_ext vss_escape sky130_fd_pr__nfet_01v8 ad=3.36 pd=8 as=3.12 ps=7.6 w=1.2 l=0.6
X8 iso_tail_ext sar_comparator_input latch_sense_n_ext vss_escape sky130_fd_pr__nfet_01v8 ad=3.12 pd=7.6 as=3.36 ps=8 w=1.2 l=0.6
X9 decision_p reset vdd_ext vdd_ext sky130_fd_pr__pfet_01v8 ad=3.36 pd=8 as=3.12 ps=7.6 w=1.2 l=0.6
X10 decision_p decision_n tail_ext vss_escape sky130_fd_pr__nfet_01v8 ad=3.36 pd=8 as=3.12 ps=7.6 w=1.2 l=0.6
C0 sar_readout_12b_0.vdd iso_tail_ext 0.27521f
C1 vdd_ext shared_converter_mux_0.mux_bus 0.00217f
C2 eval vdd_ext 0
C3 vdd_ext shared_converter_mux_0.vdd 0
C4 latch_sense_p_ext vdd_ext 3.83973f
C5 m1_68300_3080# row_drive 2.68328f
C6 latch_sense_n_ext vdd_ext 3.48574f
C7 vdd_ext reset 4.48789f
C8 row_drive sar_readout_12b_0.vdd 0.58157f
C9 decision_n decision_p 2.54301f
C10 latch_sense_p_ext iso_tail_ext 0.12577f
C11 latch_sense_n_ext iso_tail_ext 0.12577f
C12 row_drive shared_converter_mux_0.mux_bus 0.06281f
C13 shared_converter_mux_0.mux_bus vss 0.03132f
C14 m1_68300_3080# sar_comparator_input 0.05195f
C15 row_drive shared_converter_mux_0.vdd 0.00246f
C16 shared_converter_mux_0.vdd vss 0.2816f
C17 vdd_ext iso_tail_ext 0.86179f
C18 latch_sense_p_ext row_drive 1.86012f
C19 latch_sense_n_ext row_drive 0.57894f
C20 latch_sense_p_ext vss 0.32714f
C21 latch_sense_n_ext vss 0.23329f
C22 tail_ext decision_p 0.48065f
C23 row_drive vdd_ext 4.04838f
C24 vdd_ext vss 0.19458f
C25 latch_sense_p_ext sar_comparator_input 1.32953f
C26 latch_sense_n_ext sar_comparator_input 0.38203f
C27 sar_readout_12b_0.vss sar_readout_12b_0.vdd 0.49712f
C28 row_drive iso_tail_ext 2.39704f
C29 latch_sense_n_ext decision_n 0.18428f
C30 row_drive row_dac_10b_0.vdd 1.11462f
C31 decision_n reset 0.31048f
C32 vdd_ext sar_comparator_input 1.56594f
C33 decision_n vdd_ext 3.9382f
C34 row_drive vss 0.44137f
C35 tail_ext eval 0.36751f
C36 iso_tail_ext sar_comparator_input 0.16721f
C37 shared_converter_mux_0.mux_bus shared_converter_mux_0.vss 1.56188f
C38 latch_sense_p_ext tail_ext 0.0334f
C39 latch_sense_n_ext tail_ext 0.0334f
C40 tail_ext reset 0.17577f
C41 sar_readout_12b_0.vss vdd_ext 0.93663f
C42 row_drive sar_comparator_input 5.41305f
C43 vss sar_comparator_input 0.09437f
C44 tail_ext vdd_ext 1.9856f
C45 row_dac_10b_0.vdd row_dac_10b_0.vss 0.78467f
C46 sar_readout_12b_0.vss iso_tail_ext 0.60045f
C47 vdd_ext shared_converter_mux_0.vss 0
C48 row_drive row_dac_10b_0.vss 1.08123f
C49 latch_sense_p_ext decision_p 0.18428f
C50 sar_readout_12b_0.vss row_drive 0.29433f
C51 reset decision_p 0.376f
C52 row_drive vdd 0.1964f
C53 decision_n sar_comparator_input 0.27273f
C54 row_drive tail_ext 0.04474f
C55 vdd_ext decision_p 3.8282f
C56 row_drive shared_converter_mux_0.vss 0.00246f
C57 tail_ext sar_comparator_input 0.21605f
C58 m1_68300_3080# vdd_ext 0.24419f
C59 shared_converter_mux_0.vdd shared_converter_mux_0.mux_bus 1.55306f
C60 decision_n tail_ext 0.48065f
C61 sar_readout_12b_0.vdd vdd_ext 1.39936f
C62 row_drive decision_p 0.02173f
C63 latch_sense_n_ext latch_sense_p_ext 0.04014f
C64 vss vss_escape 36.2336f
C65 vdd vss_escape 36.7f
C66 iso_tail_ext vss_escape 75.2611f
C67 latch_sense_n_ext vss_escape 14.9559f
C68 latch_sense_p_ext vss_escape 39.337f
C69 decision_p vss_escape 8.36234f
C70 tail_ext vss_escape 87.91016f
C71 vdd_ext vss_escape 0.25716p
C72 sar_readout_12b_0.vss vss_escape 1.33686f ; **FLOATING
C73 row_dac_10b_0.vss vss_escape 1.40333f ; **FLOATING
C74 row_dac_10b_0.vdd vss_escape 1.33457f ; **FLOATING
C75 sar_readout_12b_0.vdd vss_escape 1.77614f ; **FLOATING
C76 m1_68300_3080# vss_escape 7.89552f ; **FLOATING
C77 shared_converter_mux_0.vss vss_escape 1.39454f ; **FLOATING
C78 shared_converter_mux_0.mux_bus vss_escape 2.86922f ; **FLOATING
C79 shared_converter_mux_0.vdd vss_escape 0.95985f ; **FLOATING
.ends
