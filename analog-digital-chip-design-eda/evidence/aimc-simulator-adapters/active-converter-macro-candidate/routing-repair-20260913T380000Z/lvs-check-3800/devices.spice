* NGSPICE file created from aimc_converter_macro_active_candidate_flat.ext - technology: sky130A

* Top level circuit aimc_converter_macro_active_candidate_flat

.end
