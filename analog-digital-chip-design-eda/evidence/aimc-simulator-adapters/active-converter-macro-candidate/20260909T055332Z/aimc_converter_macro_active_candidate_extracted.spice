* NGSPICE file created from aimc_converter_macro_active_candidate.ext - technology: sky130A

.subckt escaped_input_latch out_p out_n latch_sense_p latch_sense_n tail reset vdd
+ vss eval sense_p sense_n iso_tail vdd_active
X0 out_p out_n vdd_active vdd_active sky130_fd_pr__pfet_01v8 ad=6.72 pd=10.4 as=6.24 ps=10 w=2.4 l=0.6
X1 vdd reset out_n vdd sky130_fd_pr__pfet_01v8 ad=3.12 pd=7.6 as=3.36 ps=8 w=1.2 l=0.6
X2 tail out_p out_n vss sky130_fd_pr__nfet_01v8 ad=12.48 pd=14.8 as=13.44 ps=15.2 w=4.8 l=0.6
X3 out_p reset vdd vdd sky130_fd_pr__pfet_01v8 ad=3.36 pd=8 as=3.12 ps=7.6 w=1.2 l=0.6
X4 out_p out_n tail vss sky130_fd_pr__nfet_01v8 ad=13.44 pd=15.2 as=12.48 ps=14.8 w=4.8 l=0.6
X5 tail latch_sense_n out_n vss sky130_fd_pr__nfet_01v8 ad=12.48 pd=14.8 as=13.44 ps=15.2 w=4.8 l=0.6
X6 tail eval vss vss sky130_fd_pr__nfet_01v8 ad=16.2 pd=17.4 as=16.2 ps=17.4 w=6 l=0.6
X7 out_p latch_sense_p tail vss sky130_fd_pr__nfet_01v8 ad=13.44 pd=15.2 as=12.48 ps=14.8 w=4.8 l=0.6
X8 iso_tail sense_n latch_sense_n vss sky130_fd_pr__nfet_01v8 ad=3.12 pd=7.6 as=3.36 ps=8 w=1.2 l=0.6
X9 vdd_active out_p out_n vdd_active sky130_fd_pr__pfet_01v8 ad=6.24 pd=10 as=6.72 ps=10.4 w=2.4 l=0.6
X10 latch_sense_p sense_p iso_tail vss sky130_fd_pr__nfet_01v8 ad=3.36 pd=8 as=3.12 ps=7.6 w=1.2 l=0.6
C0 vdd out_n 0.76206f
C1 latch_sense_n iso_tail 0.07366f
C2 sense_p latch_sense_p 0.02861f
C3 tail latch_sense_p 0.0334f
C4 reset out_n 0.31048f
C5 vdd_active out_n 2.87636f
C6 out_p out_n 2.60132f
C7 sense_p iso_tail 0.10725f
C8 tail vdd 0.94872f
C9 sense_n iso_tail 0.10725f
C10 latch_sense_p iso_tail 0.07366f
C11 latch_sense_n out_n 0.15901f
C12 out_p latch_sense_p 0.15901f
C13 tail vdd_active 0.94872f
C14 out_p tail 0.18071f
C15 reset vdd 4.03064f
C16 out_p vdd 0.76206f
C17 sense_n latch_sense_n 0.02861f
C18 tail latch_sense_n 0.0334f
C19 tail eval 0.09547f
C20 out_p reset 0.31048f
C21 tail out_n 0.18071f
C22 out_p vdd_active 2.82313f
C23 iso_tail vss 25.79857f
C24 latch_sense_n vss 1.99533f
C25 latch_sense_p vss 1.99533f
C26 out_n vss 9.45902f
C27 tail vss 72.30894f
C28 vdd_active vss 81.54407f
C29 vdd vss 72.40037f
.ends

.subckt aimc_converter_macro_active_candidate vss vdd row_drive sar_comparator_input
Xconverter_latch_0 converter_latch_0/out_p converter_latch_0/out_n converter_latch_0/latch_sense_p
+ converter_latch_0/latch_sense_n converter_latch_0/tail converter_latch_0/reset converter_latch_0/vdd
+ VSUBS converter_latch_0/eval row_drive sar_comparator_input converter_latch_0/iso_tail
+ converter_latch_0/vdd escaped_input_latch
C0 sar_readout_12b_0/vss converter_latch_0/iso_tail 0.60149f
C1 vss shared_converter_mux_0/vdd 0.2816f
C2 shared_converter_mux_0/vss converter_latch_0/vdd 0
C3 row_drive converter_latch_0/iso_tail 0.26293f
C4 converter_latch_0/vdd shared_converter_mux_0/vdd 0
C5 converter_latch_0/latch_sense_n vss 0.23329f
C6 shared_converter_mux_0/vss row_drive 0.00246f
C7 row_dac_10b_0/vss row_drive 1.08123f
C8 row_drive shared_converter_mux_0/vdd 0.00246f
C9 vss shared_converter_mux_0/mux_bus 0.03132f
C10 sar_readout_12b_0/vdd converter_latch_0/vdd 1.39936f
C11 shared_converter_mux_0/mux_bus converter_latch_0/vdd 0.00217f
C12 converter_latch_0/iso_tail sar_comparator_input 0.08712f
C13 vss converter_latch_0/latch_sense_p 0.23329f
C14 vdd row_drive 0.1964f
C15 sar_readout_12b_0/vdd sar_readout_12b_0/vss 0.49712f
C16 sar_readout_12b_0/vdd row_drive 0.33461f
C17 row_drive shared_converter_mux_0/mux_bus 0.06281f
C18 vss converter_latch_0/vdd 0.19458f
C19 sar_readout_12b_0/vdd converter_latch_0/iso_tail 0.27625f
C20 row_drive row_dac_10b_0/vdd 1.11409f
C21 row_drive vss 0.22445f
C22 sar_readout_12b_0/vss converter_latch_0/vdd 0.93663f
C23 row_drive converter_latch_0/vdd 1.55835f
C24 shared_converter_mux_0/vss shared_converter_mux_0/mux_bus 1.56188f
C25 shared_converter_mux_0/mux_bus shared_converter_mux_0/vdd 1.55306f
C26 sar_readout_12b_0/vss row_drive 0.21493f
C27 converter_latch_0/iso_tail converter_latch_0/vdd 0.31557f
C28 row_dac_10b_0/vss row_dac_10b_0/vdd 0.78467f
C29 vss VSUBS 30.5941f
C30 vdd VSUBS 30.5941f
C31 sar_comparator_input VSUBS 0.93057f
C32 row_drive VSUBS 6.8802f
C33 converter_latch_0/vdd VSUBS 38.5654f
.ends
