* NGSPICE file created from aimc_converter_macro_active_candidate_flat.ext - technology: sky130A

.subckt aimc_converter_macro_active_candidate_flat vss vdd row_drive sar_comparator_input
+ decision_p decision_n reset eval vss_escape latch_sense_p_ext latch_sense_n_ext
+ iso_tail_ext tail_ext vdd_ext preamp_iso_tail_ext
X0 preamp_iso_tail_ext sar_comparator_input vdd_ext vss_escape sky130_fd_pr__nfet_01v8 ad=3.12 pd=7.6 as=3.36 ps=8 w=1.2 l=0.6
X1 vdd_ext decision_p decision_n vdd_ext sky130_fd_pr__pfet_01v8 ad=3.12 pd=7.6 as=3.36 ps=8 w=1.2 l=0.6
X2 tail_ext eval vss_escape vss_escape sky130_fd_pr__nfet_01v8 ad=16.2 pd=17.4 as=16.2 ps=17.4 w=6 l=0.6
X3 latch_sense_p_ext_uq0 row_drive preamp_iso_tail_ext vss_escape sky130_fd_pr__nfet_01v8 ad=3.36 pd=8 as=3.12 ps=7.6 w=1.2 l=0.6
X4 decision_p latch_sense_p_ext tail_ext vss_escape sky130_fd_pr__nfet_01v8 ad=3.36 pd=8 as=3.12 ps=7.6 w=1.2 l=0.6
X5 vdd_ext reset decision_n vdd_ext sky130_fd_pr__pfet_01v8 ad=3.12 pd=7.6 as=3.36 ps=8 w=1.2 l=0.6
X6 tail_ext latch_sense_n_ext decision_n vss_escape sky130_fd_pr__nfet_01v8 ad=3.12 pd=7.6 as=3.36 ps=8 w=1.2 l=0.6
X7 decision_p decision_n vdd_ext vdd_ext sky130_fd_pr__pfet_01v8 ad=3.36 pd=8 as=3.12 ps=7.6 w=1.2 l=0.6
X8 tail_ext decision_p decision_n vss_escape sky130_fd_pr__nfet_01v8 ad=3.12 pd=7.6 as=3.36 ps=8 w=1.2 l=0.6
X9 latch_sense_p_ext row_drive iso_tail_ext vss_escape sky130_fd_pr__nfet_01v8 ad=3.36 pd=8 as=3.12 ps=7.6 w=1.2 l=0.6
X10 iso_tail_ext sar_comparator_input latch_sense_n_ext vss_escape sky130_fd_pr__nfet_01v8 ad=3.12 pd=7.6 as=3.36 ps=8 w=1.2 l=0.6
X11 decision_p reset vdd_ext vdd_ext sky130_fd_pr__pfet_01v8 ad=3.36 pd=8 as=3.12 ps=7.6 w=1.2 l=0.6
X12 decision_p decision_n tail_ext vss_escape sky130_fd_pr__nfet_01v8 ad=3.36 pd=8 as=3.12 ps=7.6 w=1.2 l=0.6
C0 latch_sense_p_ext_uq0 vdd_ext 0.08747f
C1 latch_sense_n_ext vdd_ext 3.48444f
C2 vdd_ext preamp_iso_tail_ext 0.37794f
C3 decision_n latch_sense_n_ext 0.18428f
C4 vss row_drive 0.22445f
C5 latch_sense_n_ext tail_ext 0.0334f
C6 vdd row_drive 0.1964f
C7 shared_converter_mux_0.vdd row_drive 0.00246f
C8 sar_readout_12b_0.vss vdd_ext 0.93663f
C9 vdd_ext row_drive 3.99398f
C10 m2_64900_1400# vdd_ext 0.66664f
C11 decision_p vdd_ext 3.8282f
C12 latch_sense_p_ext row_drive 0.6214f
C13 latch_sense_p_ext_uq0 sar_comparator_input 0.02717f
C14 latch_sense_n_ext sar_comparator_input 0.04279f
C15 decision_n decision_p 2.54301f
C16 preamp_iso_tail_ext sar_comparator_input 0.14922f
C17 latch_sense_p_ext decision_p 0.18428f
C18 decision_p tail_ext 0.48065f
C19 m1_68300_3080# vdd_ext 0.24469f
C20 shared_converter_mux_0.mux_bus vss 0.03132f
C21 sar_readout_12b_0.vdd vdd_ext 1.39936f
C22 latch_sense_p_ext_uq0 preamp_iso_tail_ext 0.03385f
C23 vdd_ext iso_tail_ext 0.86179f
C24 eval vdd_ext 0
C25 sar_comparator_input row_drive 5.29847f
C26 latch_sense_p_ext iso_tail_ext 0.12577f
C27 m2_64900_1400# sar_comparator_input 0.21578f
C28 shared_converter_mux_0.vdd shared_converter_mux_0.mux_bus 1.55306f
C29 shared_converter_mux_0.vss row_drive 0.00246f
C30 vdd_ext shared_converter_mux_0.mux_bus 0.00217f
C31 row_dac_10b_0.vdd row_drive 1.11462f
C32 eval tail_ext 0.36751f
C33 latch_sense_p_ext_uq0 row_drive 0.01847f
C34 latch_sense_p_ext_uq0 m2_64900_1400# 0.4047f
C35 latch_sense_n_ext row_drive 0.57746f
C36 preamp_iso_tail_ext row_drive 0.34336f
C37 m1_68300_3080# sar_comparator_input 0
C38 m2_64900_1400# preamp_iso_tail_ext 0.33878f
C39 iso_tail_ext sar_comparator_input 0.16721f
C40 vdd_ext reset 4.48789f
C41 latch_sense_p_ext_uq0 m1_68300_3080# 0
C42 row_dac_10b_0.vss row_dac_10b_0.vdd 0.78467f
C43 m1_68300_3080# preamp_iso_tail_ext 0.01748f
C44 decision_n reset 0.31048f
C45 sar_readout_12b_0.vss row_drive 0.29433f
C46 m2_64900_1400# row_drive 0.03691f
C47 tail_ext reset 0.17577f
C48 latch_sense_n_ext iso_tail_ext 0.12577f
C49 shared_converter_mux_0.vss shared_converter_mux_0.mux_bus 1.56188f
C50 shared_converter_mux_0.vdd vss 0.2816f
C51 vdd_ext vss 0.19458f
C52 m1_68300_3080# row_drive 2.68356f
C53 m2_64900_1400# m1_68300_3080# 0
C54 sar_readout_12b_0.vdd sar_readout_12b_0.vss 0.49712f
C55 sar_readout_12b_0.vdd row_drive 0.58157f
C56 latch_sense_p_ext vss 0.23329f
C57 sar_readout_12b_0.vss iso_tail_ext 0.60045f
C58 iso_tail_ext row_drive 2.39704f
C59 row_dac_10b_0.vss row_drive 1.08123f
C60 vdd_ext shared_converter_mux_0.vdd 0
C61 shared_converter_mux_0.mux_bus row_drive 0.06281f
C62 decision_n vdd_ext 3.9382f
C63 latch_sense_p_ext vdd_ext 3.43095f
C64 vdd_ext tail_ext 1.9856f
C65 decision_n tail_ext 0.48065f
C66 sar_readout_12b_0.vdd iso_tail_ext 0.27521f
C67 latch_sense_p_ext tail_ext 0.0334f
C68 latch_sense_n_ext vss 0.23329f
C69 vdd_ext sar_comparator_input 1.12426f
C70 decision_p reset 0.376f
C71 shared_converter_mux_0.vss vdd_ext 0
C72 vss vss_escape 36.2292f
C73 vdd vss_escape 36.7f
C74 preamp_iso_tail_ext vss_escape 49.25016f
C75 iso_tail_ext vss_escape 20.9682f
C76 decision_p vss_escape 7.38983f
C77 tail_ext vss_escape 81.08725f
C78 vdd_ext vss_escape 0.26773p
C79 m2_64900_1400# vss_escape 0.69089f ; **FLOATING
C80 sar_readout_12b_0.vss vss_escape 1.33686f ; **FLOATING
C81 row_dac_10b_0.vss vss_escape 1.40333f ; **FLOATING
C82 row_dac_10b_0.vdd vss_escape 1.33457f ; **FLOATING
C83 sar_readout_12b_0.vdd vss_escape 1.77614f ; **FLOATING
C84 m1_68300_3080# vss_escape 7.90194f ; **FLOATING
C85 shared_converter_mux_0.vss vss_escape 1.39454f ; **FLOATING
C86 shared_converter_mux_0.mux_bus vss_escape 2.86922f ; **FLOATING
C87 shared_converter_mux_0.vdd vss_escape 0.95985f ; **FLOATING
C88 latch_sense_p_ext_uq0 vss_escape 37.14843f
.ends
