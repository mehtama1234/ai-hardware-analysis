* NGSPICE file created from aimc_converter_macro_active_candidate_flat.ext - technology: sky130A

.subckt aimc_converter_macro_active_candidate_flat vss vdd row_drive sar_comparator_input
+ decision_p reset eval vss_escape iso_tail_ext vdd_ext
X0 vdd_ext physical_preamp_n.sar_comparator_input vdd_ext vss_escape sky130_fd_pr__nfet_01v8 ad=3.12 pd=7.6 as=57.48 ps=123.8 w=1.2 l=0.6
X1 vdd_ext decision_p vdd_ext vdd_ext sky130_fd_pr__pfet_01v8 ad=3.36 pd=8 as=19.2 ps=46.4 w=1.2 l=0.6
X2 vdd_ext eval vss_escape vss_escape sky130_fd_pr__nfet_01v8 ad=16.2 pd=17.4 as=16.2 ps=17.4 w=6 l=0.6
X3 decision_p vdd_ext vdd_ext vss_escape sky130_fd_pr__nfet_01v8 ad=3.36 pd=8 as=3.12 ps=7.6 w=1.2 l=0.6
X4 vdd_ext reset vdd_ext vdd_ext sky130_fd_pr__pfet_01v8 ad=3.36 pd=8 as=0 ps=0 w=1.2 l=0.6
X5 vdd_ext vdd_ext vdd_ext vss_escape sky130_fd_pr__nfet_01v8 ad=3.36 pd=8 as=0 ps=0 w=1.2 l=0.6
X6 decision_p vdd_ext vdd_ext vdd_ext sky130_fd_pr__pfet_01v8 ad=3.36 pd=8 as=3.12 ps=7.6 w=1.2 l=0.6
X7 vdd_ext decision_p vdd_ext vss_escape sky130_fd_pr__nfet_01v8 ad=3.36 pd=8 as=0 ps=0 w=1.2 l=0.6
X8 vdd_ext row_drive iso_tail_ext vss_escape sky130_fd_pr__nfet_01v8 ad=3.36 pd=8 as=3.12 ps=7.6 w=1.2 l=0.6
X9 iso_tail_ext sar_comparator_input vdd_ext vss_escape sky130_fd_pr__nfet_01v8 ad=3.12 pd=7.6 as=3.36 ps=8 w=1.2 l=0.6
X10 vdd_ext row_drive vdd_ext vss_escape sky130_fd_pr__nfet_01v8 ad=3.12 pd=7.6 as=0 ps=0 w=1.2 l=0.6
X11 decision_p reset vdd_ext vdd_ext sky130_fd_pr__pfet_01v8 ad=3.36 pd=8 as=3.12 ps=7.6 w=1.2 l=0.6
X12 decision_p vdd_ext vdd_ext vss_escape sky130_fd_pr__nfet_01v8 ad=3.36 pd=8 as=3.12 ps=7.6 w=1.2 l=0.6
C0 shared_converter_mux_0.mux_bus shared_converter_mux_0.vss 1.56188f
C1 vdd_ext vss 0.79123f
C2 m4_45060_36440# vdd_ext 0.06632f
C3 shared_converter_mux_0.vss row_drive 0.00246f
C4 iso_tail_ext vdd_ext 1.12013f
C5 iso_tail_ext sar_readout_12b_0.vss 0.60045f
C6 physical_preamp_n.sar_comparator_input m4_51060_36440# 0.12952f
C7 physical_preamp_n.sar_comparator_input vdd_ext 0.68155f
C8 reset vdd_ext 5.16943f
C9 sar_readout_12b_0.vdd row_drive 0.58157f
C10 shared_converter_mux_0.mux_bus row_drive 0.06281f
C11 sar_comparator_input row_drive 5.22878f
C12 m4_51060_36440# vdd_ext 0.02005f
C13 shared_converter_mux_0.vdd shared_converter_mux_0.mux_bus 1.55306f
C14 m1_68300_3080# row_drive 2.68328f
C15 shared_converter_mux_0.vdd row_drive 0.00246f
C16 shared_converter_mux_0.mux_bus vss 0.03132f
C17 row_dac_10b_0.vdd row_dac_10b_0.vss 0.78467f
C18 iso_tail_ext sar_readout_12b_0.vdd 0.27521f
C19 vdd_ext sar_readout_12b_0.vss 0.93663f
C20 row_drive vss 0.22445f
C21 m4_45060_36440# row_drive 0.12597f
C22 sar_comparator_input iso_tail_ext 0.16721f
C23 iso_tail_ext row_drive 2.39704f
C24 vdd_ext shared_converter_mux_0.vss 0
C25 shared_converter_mux_0.vdd vss 0.2816f
C26 vdd_ext eval 0.56561f
C27 decision_p reset 0.376f
C28 physical_preamp_n.sar_comparator_input row_drive 0.12269f
C29 row_drive vdd 0.1964f
C30 vdd_ext sar_readout_12b_0.vdd 1.39936f
C31 vdd_ext shared_converter_mux_0.mux_bus 0.00217f
C32 decision_p vdd_ext 7.2282f
C33 sar_comparator_input vdd_ext 1.11029f
C34 vdd_ext row_drive 6.19357f
C35 row_dac_10b_0.vdd row_drive 1.11462f
C36 sar_readout_12b_0.vdd sar_readout_12b_0.vss 0.49712f
C37 row_dac_10b_0.vss row_drive 1.08123f
C38 vdd_ext m1_68300_3080# 0.24419f
C39 shared_converter_mux_0.vdd vdd_ext 0
C40 sar_readout_12b_0.vss row_drive 0.29433f
C41 vss vss_escape 36.2394f
C42 vdd vss_escape 36.7f
C43 iso_tail_ext vss_escape 77.06784f
C44 decision_p vss_escape 0.12839p
C45 m4_51060_36440# vss_escape 0.11845f ; **FLOATING
C46 m4_45060_36440# vss_escape 0.09675f ; **FLOATING
C47 sar_readout_12b_0.vss vss_escape 1.33686f ; **FLOATING
C48 row_dac_10b_0.vss vss_escape 1.40333f ; **FLOATING
C49 row_dac_10b_0.vdd vss_escape 1.33457f ; **FLOATING
C50 sar_readout_12b_0.vdd vss_escape 1.77614f ; **FLOATING
C51 m1_68300_3080# vss_escape 7.89552f ; **FLOATING
C52 shared_converter_mux_0.vss vss_escape 1.39454f ; **FLOATING
C53 shared_converter_mux_0.mux_bus vss_escape 2.86922f ; **FLOATING
C54 shared_converter_mux_0.vdd vss_escape 0.95985f ; **FLOATING
.ends
