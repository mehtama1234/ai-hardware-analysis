* NGSPICE file created from aimc_converter_macro_active_candidate_flat.ext - technology: sky130A

.subckt aimc_converter_macro_active_candidate_flat vss vdd sar_comparator_input decision_p
+ decision_n reset eval vss_escape latch_sense_n_ext iso_tail_ext tail_ext vdd_ext
X0 vdd_ext decision_p decision_n vdd_ext sky130_fd_pr__pfet_01v8 ad=3.12 pd=7.6 as=3.36 ps=8 w=1.2 l=0.6
X1 tail_ext eval vss_escape vss_escape sky130_fd_pr__nfet_01v8 ad=16.2 pd=17.4 as=16.2 ps=17.4 w=6 l=0.6
X2 latch_sense_n_ext sar_comparator_input vdd_ext vss_escape sky130_fd_pr__nfet_01v8 ad=3.36 pd=8 as=3.12 ps=7.6 w=1.2 l=0.6
X3 decision_p vdd_ext tail_ext vss_escape sky130_fd_pr__nfet_01v8 ad=3.36 pd=8 as=3.12 ps=7.6 w=1.2 l=0.6
X4 vdd_ext reset decision_n vdd_ext sky130_fd_pr__pfet_01v8 ad=3.12 pd=7.6 as=3.36 ps=8 w=1.2 l=0.6
X5 tail_ext latch_sense_n_ext decision_n vss_escape sky130_fd_pr__nfet_01v8 ad=3.12 pd=7.6 as=3.36 ps=8 w=1.2 l=0.6
X6 decision_p decision_n vdd_ext vdd_ext sky130_fd_pr__pfet_01v8 ad=3.36 pd=8 as=3.12 ps=7.6 w=1.2 l=0.6
X7 tail_ext decision_p decision_n vss_escape sky130_fd_pr__nfet_01v8 ad=3.12 pd=7.6 as=3.36 ps=8 w=1.2 l=0.6
X8 vdd_ext vdd_ext iso_tail_ext vss_escape sky130_fd_pr__nfet_01v8 ad=3.36 pd=8 as=3.12 ps=7.6 w=1.2 l=0.6
X9 iso_tail_ext sar_comparator_input latch_sense_n_ext vss_escape sky130_fd_pr__nfet_01v8 ad=3.12 pd=7.6 as=3.36 ps=8 w=1.2 l=0.6
X10 decision_p reset vdd_ext vdd_ext sky130_fd_pr__pfet_01v8 ad=3.36 pd=8 as=3.12 ps=7.6 w=1.2 l=0.6
X11 vdd_ext vdd_ext vdd_ext vss_escape sky130_fd_pr__nfet_01v8 ad=3.12 pd=7.6 as=15.36 ps=44 w=1.2 l=0.6
X12 decision_p decision_n tail_ext vss_escape sky130_fd_pr__nfet_01v8 ad=3.36 pd=8 as=3.12 ps=7.6 w=1.2 l=0.6
C0 vdd_ext row_dac_10b_0.vss 1.08123f
C1 tail_ext eval 0.36751f
C2 tail_ext latch_sense_n_ext 0.0334f
C3 vdd_ext iso_tail_ext 3.3846f
C4 m1_68300_3080# sar_comparator_input 0.05195f
C5 decision_n sar_comparator_input 0.27273f
C6 vss sar_comparator_input 0.09437f
C7 decision_n decision_p 2.54301f
C8 vdd_ext sar_readout_12b_0.vss 1.23096f
C9 shared_converter_mux_0.mux_bus shared_converter_mux_0.vss 1.56188f
C10 vss shared_converter_mux_0.mux_bus 0.03132f
C11 vdd_ext m1_68300_3080# 2.92746f
C12 vdd_ext decision_n 3.9382f
C13 vdd_ext shared_converter_mux_0.vss 0.00313f
C14 vss vdd_ext 0.93037f
C15 vdd_ext sar_comparator_input 8.56223f
C16 row_dac_10b_0.vdd row_dac_10b_0.vss 0.78467f
C17 vdd_ext decision_p 4.13906f
C18 latch_sense_n_ext iso_tail_ext 0.12577f
C19 shared_converter_mux_0.mux_bus vdd_ext 0.06497f
C20 sar_readout_12b_0.vdd iso_tail_ext 0.27521f
C21 tail_ext decision_n 0.48065f
C22 reset decision_n 0.31048f
C23 shared_converter_mux_0.vdd vss 0.2816f
C24 tail_ext sar_comparator_input 0.21605f
C25 tail_ext decision_p 0.48065f
C26 sar_readout_12b_0.vss sar_readout_12b_0.vdd 0.49712f
C27 reset decision_p 0.376f
C28 shared_converter_mux_0.vdd shared_converter_mux_0.mux_bus 1.55306f
C29 latch_sense_n_ext decision_n 0.18428f
C30 vss latch_sense_n_ext 0.23329f
C31 tail_ext vdd_ext 2.06374f
C32 reset vdd_ext 4.48789f
C33 latch_sense_n_ext sar_comparator_input 0.49423f
C34 shared_converter_mux_0.vdd vdd_ext 0.00313f
C35 vdd vdd_ext 0.1964f
C36 sar_readout_12b_0.vss iso_tail_ext 0.60045f
C37 eval vdd_ext 0
C38 vdd_ext latch_sense_n_ext 4.47887f
C39 reset tail_ext 0.17577f
C40 sar_comparator_input iso_tail_ext 0.16721f
C41 vdd_ext sar_readout_12b_0.vdd 1.98093f
C42 vdd_ext row_dac_10b_0.vdd 1.11462f
C43 vss vss_escape 36.1986f
C44 vdd vss_escape 36.7f
C45 iso_tail_ext vss_escape 38.1516f
C46 decision_p vss_escape 49.83442f
C47 tail_ext vss_escape 0.38221p
C48 sar_readout_12b_0.vss vss_escape 1.33686f ; **FLOATING
C49 row_dac_10b_0.vss vss_escape 1.40333f ; **FLOATING
C50 row_dac_10b_0.vdd vss_escape 1.33457f ; **FLOATING
C51 sar_readout_12b_0.vdd vss_escape 1.77614f ; **FLOATING
C52 m1_68300_3080# vss_escape 7.89552f ; **FLOATING
C53 shared_converter_mux_0.vss vss_escape 1.39454f ; **FLOATING
C54 shared_converter_mux_0.mux_bus vss_escape 2.86922f ; **FLOATING
C55 shared_converter_mux_0.vdd vss_escape 0.95985f ; **FLOATING
.ends
