* NGSPICE file created from aimc_converter_macro_active_candidate.ext - technology: sky130A

.subckt sky130_transistor_active_isolation_pair iso_tail iso_p iso_n sense_p sense_n
+ VSUBS
X0 iso_tail sense_n iso_n VSUBS sky130_fd_pr__nfet_01v8 ad=3.12 pd=7.6 as=3.36 ps=8 w=1.2 l=0.6
X1 iso_p sense_p iso_tail VSUBS sky130_fd_pr__nfet_01v8 ad=3.36 pd=8 as=3.12 ps=7.6 w=1.2 l=0.6
C0 iso_n m1_3440_500# 0.0015f
C1 sense_p iso_tail 0.12292f
C2 iso_p m1_1000_500# 0.0015f
C3 sense_n iso_n 0.02157f
C4 iso_p iso_n 0.00782f
C5 iso_tail m2_900_1400# 0.34398f
C6 iso_tail m1_3440_500# 0.0015f
C7 sense_n iso_tail 0.11179f
C8 iso_p iso_tail 0.05749f
C9 sense_p m2_900_1400# 0.04273f
C10 m1_1000_500# iso_tail 0.0015f
C11 iso_p sense_p 0.02157f
C12 iso_n iso_tail 0.05717f
C13 m1_3440_500# m2_900_1400# 0.01113f
C14 sense_n m2_900_1400# 0.04273f
C15 iso_p m2_900_1400# 0.41846f
C16 sense_p m1_1000_500# 0.04555f
C17 sense_n m1_3440_500# 0.04555f
C18 m1_1000_500# m2_900_1400# 0.01113f
C19 iso_n m2_900_1400# 0.41846f
C20 iso_n VSUBS 1.04634f
C21 iso_p VSUBS 1.04634f
C22 iso_tail VSUBS 4.24257f
C23 m2_900_1400# VSUBS 1.01648f ; **FLOATING
C24 m1_3440_500# VSUBS 0.31893f ; **FLOATING
C25 m1_1000_500# VSUBS 0.31893f ; **FLOATING
.ends

.subckt escaped_input_latch out_p out_n latch_sense_p latch_sense_n tail reset vdd
+ vss eval sense_p sense_n iso_tail vdd_active
X0 out_p out_n vdd_active vdd_active sky130_fd_pr__pfet_01v8 ad=3.36 pd=8 as=3.12 ps=7.6 w=1.2 l=0.6
X1 vdd reset out_n vdd sky130_fd_pr__pfet_01v8 ad=3.12 pd=7.6 as=3.36 ps=8 w=1.2 l=0.6
X2 tail out_p out_n vss sky130_fd_pr__nfet_01v8 ad=3.12 pd=7.6 as=3.36 ps=8 w=1.2 l=0.6
X3 out_p reset vdd vdd sky130_fd_pr__pfet_01v8 ad=3.36 pd=8 as=3.12 ps=7.6 w=1.2 l=0.6
X4 out_p out_n tail vss sky130_fd_pr__nfet_01v8 ad=3.36 pd=8 as=3.12 ps=7.6 w=1.2 l=0.6
X5 tail latch_sense_n out_n vss sky130_fd_pr__nfet_01v8 ad=3.12 pd=7.6 as=3.36 ps=8 w=1.2 l=0.6
X6 tail eval vss vss sky130_fd_pr__nfet_01v8 ad=16.2 pd=17.4 as=16.2 ps=17.4 w=6 l=0.6
X7 out_p latch_sense_p tail vss sky130_fd_pr__nfet_01v8 ad=3.36 pd=8 as=3.12 ps=7.6 w=1.2 l=0.6
X8 iso_tail sense_n latch_sense_n vss sky130_fd_pr__nfet_01v8 ad=3.12 pd=7.6 as=3.36 ps=8 w=1.2 l=0.6
X9 vdd_active out_p out_n vdd_active sky130_fd_pr__pfet_01v8 ad=3.12 pd=7.6 as=3.36 ps=8 w=1.2 l=0.6
X10 latch_sense_p sense_p iso_tail vss sky130_fd_pr__nfet_01v8 ad=3.36 pd=8 as=3.12 ps=7.6 w=1.2 l=0.6
C0 vdd_active tail 0.9938f
C1 reset out_n 0.31048f
C2 reset out_p 0.376f
C3 latch_sense_n iso_tail 0.20888f
C4 tail vdd 0.9918f
C5 sense_p latch_sense_p 0.22977f
C6 sense_n iso_tail 0.10725f
C7 iso_tail latch_sense_p 0.20888f
C8 out_p out_n 2.54301f
C9 latch_sense_n out_n 0.18428f
C10 eval tail 0.35666f
C11 reset tail 0.16491f
C12 latch_sense_n sense_n 0.22977f
C13 out_p latch_sense_p 0.18428f
C14 out_n tail 0.46979f
C15 out_p tail 0.46979f
C16 latch_sense_n tail 0.0334f
C17 tail latch_sense_p 0.0334f
C18 reset vdd 4.47121f
C19 vdd_active out_n 3.16716f
C20 out_p vdd_active 3.06556f
C21 sense_p iso_tail 0.26105f
C22 out_n vdd 0.77104f
C23 out_p vdd 0.76206f
C24 iso_tail vss 29.23796f
C25 latch_sense_n vss 1.7693f
C26 latch_sense_p vss 1.56796f
C27 out_n vss 13.58747f
C28 tail vss 89.03816f
C29 vdd_active vss 90.11912f
C30 vdd vss 78.65506f
.ends

.subckt aimc_converter_macro_active_candidate vss vdd row_drive sar_comparator_input
+ decision_p decision_n reset eval vss_escape latch_sense_p_ext latch_sense_n_ext
+ iso_tail_ext tail_ext vdd_ext
Xphysical_preamp_0 physical_preamp_0/iso_tail physical_preamp_0/iso_p physical_preamp_0/iso_n
+ physical_preamp_0/sense_p physical_preamp_0/sense_n vss_escape sky130_transistor_active_isolation_pair
Xconverter_latch_0 decision_p decision_n latch_sense_p_ext latch_sense_n_ext tail_ext
+ reset vdd_ext vss_escape eval row_drive sar_comparator_input iso_tail_ext vdd_ext
+ escaped_input_latch
C0 iso_tail_ext sar_readout_12b_0/vss 0.60149f
C1 row_drive vdd_ext 1.55835f
C2 shared_converter_mux_0/vdd vss 0.2816f
C3 tail_ext decision_p 0.01085f
C4 shared_converter_mux_0/vdd vdd_ext 0
C5 shared_converter_mux_0/vss vdd_ext 0
C6 reset vdd_ext 0.01669f
C7 vss shared_converter_mux_0/mux_bus 0.03132f
C8 row_drive shared_converter_mux_0/vdd 0.00246f
C9 sar_readout_12b_0/vdd vdd_ext 1.39936f
C10 vdd_ext shared_converter_mux_0/mux_bus 0.00217f
C11 shared_converter_mux_0/vss row_drive 0.00246f
C12 row_dac_10b_0/vss row_dac_10b_0/vdd 0.78467f
C13 row_drive vdd 0.1964f
C14 row_drive sar_readout_12b_0/vdd 0.33461f
C15 sar_readout_12b_0/vss vdd_ext 0.93663f
C16 row_drive shared_converter_mux_0/mux_bus 0.06281f
C17 eval vdd_ext 0
C18 shared_converter_mux_0/vdd shared_converter_mux_0/mux_bus 1.55306f
C19 decision_p vdd_ext 0
C20 row_drive sar_readout_12b_0/vss 0.21493f
C21 iso_tail_ext vdd_ext 0.31557f
C22 shared_converter_mux_0/vss shared_converter_mux_0/mux_bus 1.56188f
C23 vss latch_sense_n_ext 0.23329f
C24 row_drive row_dac_10b_0/vss 1.08123f
C25 row_drive iso_tail_ext 0.26323f
C26 vss latch_sense_p_ext 0.23329f
C27 sar_readout_12b_0/vdd sar_readout_12b_0/vss 0.49712f
C28 tail_ext decision_n 0.01085f
C29 tail_ext reset 0.01085f
C30 sar_comparator_input iso_tail_ext 0.08712f
C31 vss vdd_ext 0.19458f
C32 row_drive latch_sense_p_ext 0
C33 row_drive row_dac_10b_0/vdd 1.11409f
C34 iso_tail_ext sar_readout_12b_0/vdd 0.27625f
C35 row_drive vss 0.22445f
C36 tail_ext eval 0.01085f
C37 vss vss_escape 30.5941f
C38 vdd vss_escape 30.5941f
C39 iso_tail_ext vss_escape -0.88568f
C40 sar_comparator_input vss_escape 1.15812f
C41 decision_n vss_escape 3.8093f
C42 eval vss_escape 0.78348f
C43 row_drive vss_escape 7.1806f
C44 vdd_ext vss_escape 34.16415f
.ends
