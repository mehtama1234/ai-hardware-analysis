* NGSPICE file created from aimc_converter_macro_active_candidate_flat.ext - technology: sky130A

.subckt aimc_converter_macro_active_candidate_flat vss vdd row_drive sar_comparator_input
+ decision_p decision_n reset eval vss_escape latch_sense_p_ext latch_sense_n_ext
+ iso_tail_ext tail_ext vdd_ext
X0 latch_sense_n_ext physical_preamp_n.sar_comparator_input preamp_iso_tail_ext vss_escape sky130_fd_pr__nfet_01v8 ad=3.36 pd=8 as=3.12 ps=7.6 w=1.2 l=0.6
X1 vdd_ext decision_p decision_n vdd_ext sky130_fd_pr__pfet_01v8 ad=3.12 pd=7.6 as=3.36 ps=8 w=1.2 l=0.6
X2 tail_ext eval vss_escape vss_escape sky130_fd_pr__nfet_01v8 ad=16.2 pd=17.4 as=16.2 ps=17.4 w=6 l=0.6
X3 decision_p latch_sense_p_ext tail_ext vss_escape sky130_fd_pr__nfet_01v8 ad=3.36 pd=8 as=3.12 ps=7.6 w=1.2 l=0.6
X4 vdd_ext reset decision_n vdd_ext sky130_fd_pr__pfet_01v8 ad=3.12 pd=7.6 as=3.36 ps=8 w=1.2 l=0.6
X5 tail_ext latch_sense_n_ext decision_n vss_escape sky130_fd_pr__nfet_01v8 ad=3.12 pd=7.6 as=3.36 ps=8 w=1.2 l=0.6
X6 decision_p decision_n vdd_ext vdd_ext sky130_fd_pr__pfet_01v8 ad=3.36 pd=8 as=3.12 ps=7.6 w=1.2 l=0.6
X7 tail_ext decision_p decision_n vss_escape sky130_fd_pr__nfet_01v8 ad=3.12 pd=7.6 as=3.36 ps=8 w=1.2 l=0.6
X8 latch_sense_p_ext row_drive iso_tail_ext vss_escape sky130_fd_pr__nfet_01v8 ad=3.36 pd=8 as=3.12 ps=7.6 w=1.2 l=0.6
X9 iso_tail_ext sar_comparator_input latch_sense_n_ext vss_escape sky130_fd_pr__nfet_01v8 ad=3.12 pd=7.6 as=3.36 ps=8 w=1.2 l=0.6
X10 latch_sense_p_ext row_drive physical_preamp_p.preamp_iso_tail_ext vss_escape sky130_fd_pr__nfet_01v8 ad=3.36 pd=8 as=3.12 ps=7.6 w=1.2 l=0.6
X11 decision_p reset vdd_ext vdd_ext sky130_fd_pr__pfet_01v8 ad=3.36 pd=8 as=3.12 ps=7.6 w=1.2 l=0.6
X12 decision_p decision_n tail_ext vss_escape sky130_fd_pr__nfet_01v8 ad=3.36 pd=8 as=3.12 ps=7.6 w=1.2 l=0.6
C0 sar_comparator_input iso_tail_ext 0.16721f
C1 m4_45060_36440# row_drive 0.12399f
C2 row_drive row_dac_10b_0.vdd 1.11462f
C3 iso_tail_ext latch_sense_n_ext 0.12999f
C4 decision_n reset 0.31048f
C5 iso_tail_ext vdd_ext 0.86179f
C6 physical_preamp_n.sar_comparator_input latch_sense_n_ext 0.21078f
C7 shared_converter_mux_0.vdd shared_converter_mux_0.mux_bus 1.55306f
C8 shared_converter_mux_0.vss row_drive 0.00246f
C9 physical_preamp_n.sar_comparator_input vdd_ext 0.01545f
C10 sar_readout_12b_0.vss vdd_ext 0.93663f
C11 vss row_drive 0.22445f
C12 reset latch_sense_p_ext 0.19529f
C13 eval tail_ext 0.36751f
C14 decision_n latch_sense_n_ext 0.37635f
C15 decision_n vdd_ext 3.9382f
C16 sar_readout_12b_0.vdd vdd_ext 1.39936f
C17 latch_sense_n_ext latch_sense_p_ext 0.59927f
C18 decision_p tail_ext 0.48065f
C19 vdd_ext latch_sense_p_ext 5.38463f
C20 preamp_iso_tail_ext latch_sense_n_ext 0.08711f
C21 preamp_iso_tail_ext vdd_ext 0.00772f
C22 shared_converter_mux_0.vdd vdd_ext 0
C23 physical_preamp_p.preamp_iso_tail_ext latch_sense_p_ext 0.10708f
C24 shared_converter_mux_0.mux_bus vdd_ext 0.00217f
C25 iso_tail_ext row_drive 2.39704f
C26 physical_preamp_n.sar_comparator_input row_drive 0.12269f
C27 m4_32000_38940# latch_sense_p_ext 0.00354f
C28 m4_45060_36440# latch_sense_p_ext 0.00708f
C29 sar_readout_12b_0.vss row_drive 0.29433f
C30 reset vdd_ext 4.48789f
C31 physical_preamp_n.sar_comparator_input m4_51060_36440# 0.12862f
C32 sar_comparator_input latch_sense_n_ext 0.04367f
C33 eval latch_sense_p_ext 0.19752f
C34 sar_comparator_input vdd_ext 1.06679f
C35 decision_n decision_p 2.54301f
C36 vdd row_drive 0.1964f
C37 vss latch_sense_p_ext 0.29037f
C38 sar_readout_12b_0.vdd row_drive 0.58157f
C39 vss shared_converter_mux_0.vdd 0.2816f
C40 latch_sense_n_ext vdd_ext 4.55721f
C41 decision_n tail_ext 0.48065f
C42 row_drive latch_sense_p_ext 0.96452f
C43 shared_converter_mux_0.vss shared_converter_mux_0.mux_bus 1.56188f
C44 decision_p latch_sense_p_ext 0.37635f
C45 row_dac_10b_0.vdd row_dac_10b_0.vss 0.78467f
C46 shared_converter_mux_0.vdd row_drive 0.00246f
C47 sar_readout_12b_0.vss iso_tail_ext 0.60045f
C48 vss shared_converter_mux_0.mux_bus 0.03132f
C49 tail_ext latch_sense_p_ext 0.99589f
C50 physical_preamp_p.preamp_iso_tail_ext latch_sense_n_ext 0.01408f
C51 physical_preamp_p.preamp_iso_tail_ext vdd_ext 0.00299f
C52 m4_51060_36440# preamp_iso_tail_ext 0.00179f
C53 shared_converter_mux_0.mux_bus row_drive 0.06281f
C54 m1_68300_3080# vdd_ext 0.24419f
C55 m4_32000_38940# latch_sense_n_ext 0.0096f
C56 m4_45060_36440# latch_sense_n_ext 0.00655f
C57 m4_45060_36440# vdd_ext 0.01404f
C58 row_drive row_dac_10b_0.vss 1.08123f
C59 sar_readout_12b_0.vdd iso_tail_ext 0.27521f
C60 decision_p reset 0.376f
C61 iso_tail_ext latch_sense_p_ext 0.1295f
C62 sar_readout_12b_0.vss sar_readout_12b_0.vdd 0.49712f
C63 shared_converter_mux_0.vss vdd_ext 0
C64 m4_45060_36440# physical_preamp_p.preamp_iso_tail_ext 0
C65 eval vdd_ext 0
C66 reset tail_ext 0.17577f
C67 physical_preamp_n.sar_comparator_input preamp_iso_tail_ext 0.10062f
C68 sar_comparator_input row_drive 5.22878f
C69 vss latch_sense_n_ext 0.29037f
C70 vss vdd_ext 0.19458f
C71 row_drive latch_sense_n_ext 0.75847f
C72 row_drive vdd_ext 3.83977f
C73 decision_p vdd_ext 3.8282f
C74 latch_sense_n_ext tail_ext 1.09601f
C75 m4_51060_36440# latch_sense_n_ext 0.00671f
C76 tail_ext vdd_ext 1.9856f
C77 m4_51060_36440# vdd_ext 0.01404f
C78 physical_preamp_p.preamp_iso_tail_ext row_drive 0.10062f
C79 m1_68300_3080# row_drive 2.68328f
C80 vss vss_escape 36.2394f
C81 vdd vss_escape 36.7f
C82 iso_tail_ext vss_escape 77.07605f
C83 decision_p vss_escape 12.34801f
C84 tail_ext vss_escape 0.12268p
C85 latch_sense_n_ext vss_escape 9.0153f
C86 latch_sense_p_ext vss_escape 47.09255f
C87 vdd_ext vss_escape 0.26074p
C88 m4_51060_36440# vss_escape 0.11856f ; **FLOATING
C89 m4_45060_36440# vss_escape 0.10718f ; **FLOATING
C90 m4_32000_38940# vss_escape 0.1568f ; **FLOATING
C91 sar_readout_12b_0.vss vss_escape 1.33686f ; **FLOATING
C92 row_dac_10b_0.vss vss_escape 1.40333f ; **FLOATING
C93 row_dac_10b_0.vdd vss_escape 1.33457f ; **FLOATING
C94 sar_readout_12b_0.vdd vss_escape 1.77614f ; **FLOATING
C95 m1_68300_3080# vss_escape 7.89552f ; **FLOATING
C96 shared_converter_mux_0.vss vss_escape 1.39454f ; **FLOATING
C97 shared_converter_mux_0.mux_bus vss_escape 2.86922f ; **FLOATING
C98 shared_converter_mux_0.vdd vss_escape 0.95985f ; **FLOATING
C99 preamp_iso_tail_ext vss_escape 4.51515f
C100 physical_preamp_p.preamp_iso_tail_ext vss_escape 0.38054f
.ends
