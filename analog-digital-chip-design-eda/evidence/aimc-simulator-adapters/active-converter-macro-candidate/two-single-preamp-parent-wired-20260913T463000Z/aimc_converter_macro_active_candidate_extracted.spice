* NGSPICE file created from aimc_converter_macro_active_candidate_flat.ext - technology: sky130A

.subckt aimc_converter_macro_active_candidate_flat vss vdd row_drive sar_comparator_input
+ decision_p decision_n reset eval vss_escape latch_sense_p_ext latch_sense_n_ext
+ iso_tail_ext tail_ext vdd_ext
X0 vdd_ext decision_p decision_n vdd_ext sky130_fd_pr__pfet_01v8 ad=3.12 pd=7.6 as=3.36 ps=8 w=1.2 l=0.6
X1 tail_ext eval vss_escape vss_escape sky130_fd_pr__nfet_01v8 ad=16.2 pd=17.4 as=16.2 ps=17.4 w=6 l=0.6
X2 latch_sense_n_ext sar_comparator_input latch_sense_p_ext vss_escape sky130_fd_pr__nfet_01v8 ad=3.36 pd=8 as=3.12 ps=7.6 w=1.2 l=0.6
X3 decision_p latch_sense_p_ext tail_ext vss_escape sky130_fd_pr__nfet_01v8 ad=3.36 pd=8 as=3.12 ps=7.6 w=1.2 l=0.6
X4 vdd_ext reset decision_n vdd_ext sky130_fd_pr__pfet_01v8 ad=3.12 pd=7.6 as=3.36 ps=8 w=1.2 l=0.6
X5 tail_ext latch_sense_n_ext decision_n vss_escape sky130_fd_pr__nfet_01v8 ad=3.12 pd=7.6 as=3.36 ps=8 w=1.2 l=0.6
X6 decision_p decision_n vdd_ext vdd_ext sky130_fd_pr__pfet_01v8 ad=3.36 pd=8 as=3.12 ps=7.6 w=1.2 l=0.6
X7 tail_ext decision_p decision_n vss_escape sky130_fd_pr__nfet_01v8 ad=3.12 pd=7.6 as=3.36 ps=8 w=1.2 l=0.6
X8 latch_sense_p_ext row_drive iso_tail_ext vss_escape sky130_fd_pr__nfet_01v8 ad=3.36 pd=8 as=3.12 ps=7.6 w=1.2 l=0.6
X9 iso_tail_ext sar_comparator_input latch_sense_n_ext vss_escape sky130_fd_pr__nfet_01v8 ad=3.12 pd=7.6 as=3.36 ps=8 w=1.2 l=0.6
X10 decision_p reset vdd_ext vdd_ext sky130_fd_pr__pfet_01v8 ad=3.36 pd=8 as=3.12 ps=7.6 w=1.2 l=0.6
X11 latch_sense_p_ext row_drive latch_sense_p_ext vss_escape sky130_fd_pr__nfet_01v8 ad=3.12 pd=7.6 as=12.96 ps=31.2 w=1.2 l=0.6
X12 decision_p decision_n tail_ext vss_escape sky130_fd_pr__nfet_01v8 ad=3.36 pd=8 as=3.12 ps=7.6 w=1.2 l=0.6
C0 row_drive m1_68300_3080# 2.68328f
C1 sar_comparator_input m1_68300_3080# 0.05195f
C2 vdd_ext iso_tail_ext 0.86179f
C3 decision_p tail_ext 0.48065f
C4 iso_tail_ext latch_sense_n_ext 0.12577f
C5 row_drive sar_readout_12b_0.vdd 0.58157f
C6 iso_tail_ext sar_readout_12b_0.vss 0.60045f
C7 row_drive latch_sense_p_ext 2.19831f
C8 sar_comparator_input latch_sense_p_ext 1.37585f
C9 eval vdd_ext 0
C10 shared_converter_mux_0.vdd vdd_ext 0
C11 vdd_ext latch_sense_n_ext 3.50437f
C12 tail_ext latch_sense_p_ext 0.0334f
C13 vdd_ext sar_readout_12b_0.vss 0.93663f
C14 row_drive row_dac_10b_0.vdd 1.11462f
C15 latch_sense_p_ext vss 0.32714f
C16 iso_tail_ext sar_readout_12b_0.vdd 0.27521f
C17 vdd_ext decision_p 3.8282f
C18 vdd_ext shared_converter_mux_0.vss 0
C19 row_drive shared_converter_mux_0.mux_bus 0.06281f
C20 vdd_ext m1_68300_3080# 0.24419f
C21 iso_tail_ext latch_sense_p_ext 0.12577f
C22 reset decision_n 0.31048f
C23 sar_comparator_input row_drive 5.46697f
C24 vdd_ext sar_readout_12b_0.vdd 1.39936f
C25 sar_comparator_input decision_n 0.27273f
C26 reset tail_ext 0.17577f
C27 row_dac_10b_0.vss row_dac_10b_0.vdd 0.78467f
C28 row_drive tail_ext 0.04474f
C29 sar_comparator_input tail_ext 0.21605f
C30 vdd_ext latch_sense_p_ext 3.87836f
C31 shared_converter_mux_0.mux_bus vss 0.03132f
C32 tail_ext decision_n 0.48065f
C33 sar_readout_12b_0.vss sar_readout_12b_0.vdd 0.49712f
C34 latch_sense_n_ext latch_sense_p_ext 0.09108f
C35 row_drive vss 0.44137f
C36 sar_comparator_input vss 0.09437f
C37 row_drive row_dac_10b_0.vss 1.08123f
C38 row_drive iso_tail_ext 2.39704f
C39 sar_comparator_input iso_tail_ext 0.16721f
C40 decision_p latch_sense_p_ext 0.18428f
C41 vdd_ext shared_converter_mux_0.mux_bus 0.00217f
C42 vdd_ext reset 4.48789f
C43 shared_converter_mux_0.vdd shared_converter_mux_0.mux_bus 1.55306f
C44 row_drive vdd_ext 4.06888f
C45 row_drive vdd 0.1964f
C46 sar_comparator_input vdd_ext 1.59943f
C47 shared_converter_mux_0.vdd row_drive 0.00246f
C48 vdd_ext decision_n 3.9382f
C49 row_drive latch_sense_n_ext 0.60667f
C50 sar_comparator_input latch_sense_n_ext 0.47257f
C51 latch_sense_n_ext decision_n 0.18428f
C52 vdd_ext tail_ext 1.9856f
C53 eval tail_ext 0.36751f
C54 row_drive sar_readout_12b_0.vss 0.29433f
C55 latch_sense_n_ext tail_ext 0.0334f
C56 decision_p reset 0.376f
C57 vdd_ext vss 0.19458f
C58 shared_converter_mux_0.mux_bus shared_converter_mux_0.vss 1.56188f
C59 row_drive decision_p 0.02173f
C60 shared_converter_mux_0.vdd vss 0.2816f
C61 latch_sense_n_ext vss 0.23329f
C62 decision_p decision_n 2.54301f
C63 row_drive shared_converter_mux_0.vss 0.00246f
C64 vss vss_escape 36.1986f
C65 vdd vss_escape 36.7f
C66 iso_tail_ext vss_escape 61.10005f
C67 latch_sense_p_ext vss_escape 40.13185f
C68 decision_p vss_escape 11.39133f
C69 tail_ext vss_escape 0.1131p
C70 vdd_ext vss_escape 0.26109p
C71 sar_readout_12b_0.vss vss_escape 1.33686f ; **FLOATING
C72 row_dac_10b_0.vss vss_escape 1.40333f ; **FLOATING
C73 row_dac_10b_0.vdd vss_escape 1.33457f ; **FLOATING
C74 sar_readout_12b_0.vdd vss_escape 1.77614f ; **FLOATING
C75 m1_68300_3080# vss_escape 7.89552f ; **FLOATING
C76 shared_converter_mux_0.vss vss_escape 1.39454f ; **FLOATING
C77 shared_converter_mux_0.mux_bus vss_escape 2.86922f ; **FLOATING
C78 shared_converter_mux_0.vdd vss_escape 0.95985f ; **FLOATING
.ends
