* SPICE3 file created from aimc_converter_macro_active_candidate.ext - technology: sky130A

.subckt preamp_n_nfet source drain gate body
X0 drain gate source body sky130_fd_pr__nfet_01v8 ad=3.36 pd=8 as=3.12 ps=7.6 w=1.2 l=0.6
C0 gate source 0.02892f
C1 gate drain 0.02459f
C2 source drain 0.03982f
C3 drain body 1.37396f
C4 source body 1.3736f
.ends

.subckt preamp_p_nfet source drain gate body
X0 drain gate source body sky130_fd_pr__nfet_01v8 ad=3.36 pd=8 as=3.12 ps=7.6 w=1.2 l=0.6
C0 drain source 0.03982f
C1 source gate 0.02892f
C2 drain gate 0.02459f
C3 drain body 1.37396f
C4 source body 1.3736f
.ends

.subckt escaped_input_latch out_p out_n latch_sense_p latch_sense_n tail reset vdd
+ vss eval sense_p sense_n iso_tail vdd_active
X0 out_p out_n vdd_active vdd_active sky130_fd_pr__pfet_01v8 ad=3.36 pd=8 as=3.12 ps=7.6 w=1.2 l=0.6
X1 vdd reset out_n vdd sky130_fd_pr__pfet_01v8 ad=3.12 pd=7.6 as=3.36 ps=8 w=1.2 l=0.6
X2 tail out_p out_n vss sky130_fd_pr__nfet_01v8 ad=3.12 pd=7.6 as=3.36 ps=8 w=1.2 l=0.6
X3 out_p reset vdd vdd sky130_fd_pr__pfet_01v8 ad=3.36 pd=8 as=3.12 ps=7.6 w=1.2 l=0.6
X4 out_p out_n tail vss sky130_fd_pr__nfet_01v8 ad=3.36 pd=8 as=3.12 ps=7.6 w=1.2 l=0.6
X5 tail latch_sense_n out_n vss sky130_fd_pr__nfet_01v8 ad=3.12 pd=7.6 as=3.36 ps=8 w=1.2 l=0.6
X6 tail eval vss vss sky130_fd_pr__nfet_01v8 ad=16.2 pd=17.4 as=16.2 ps=17.4 w=6 l=0.6
X7 out_p latch_sense_p tail vss sky130_fd_pr__nfet_01v8 ad=3.36 pd=8 as=3.12 ps=7.6 w=1.2 l=0.6
X8 iso_tail sense_n latch_sense_n vss sky130_fd_pr__nfet_01v8 ad=3.12 pd=7.6 as=3.36 ps=8 w=1.2 l=0.6
X9 vdd_active out_p out_n vdd_active sky130_fd_pr__pfet_01v8 ad=3.12 pd=7.6 as=3.36 ps=8 w=1.2 l=0.6
X10 latch_sense_p sense_p iso_tail vss sky130_fd_pr__nfet_01v8 ad=3.36 pd=8 as=3.12 ps=7.6 w=1.2 l=0.6
C0 iso_tail sense_p 0.26105f
C1 latch_sense_n out_n 0.18428f
C2 latch_sense_p iso_tail 0.20888f
C3 reset vdd 4.47121f
C4 latch_sense_n tail 0.0334f
C5 tail out_n 0.46979f
C6 out_p out_n 2.54301f
C7 out_p tail 0.46979f
C8 sense_n iso_tail 0.10725f
C9 vdd_active out_n 3.16716f
C10 tail vdd_active 0.9938f
C11 vdd out_n 0.77104f
C12 eval tail 0.35666f
C13 out_p vdd_active 3.06556f
C14 latch_sense_p tail 0.0334f
C15 tail vdd 0.9918f
C16 latch_sense_p out_p 0.18428f
C17 out_p vdd 0.76206f
C18 latch_sense_n iso_tail 0.20888f
C19 latch_sense_n sense_n 0.22977f
C20 reset out_n 0.31048f
C21 latch_sense_p sense_p 0.22977f
C22 reset tail 0.16491f
C23 reset out_p 0.376f
C24 iso_tail vss 29.23796f
C25 latch_sense_n vss 1.7693f
C26 latch_sense_p vss 1.56796f
C27 out_n vss 13.58747f
C28 tail vss 89.03816f
C29 vdd_active vss 90.11912f
C30 vdd vss 78.65506f
.ends

.subckt aimc_converter_macro_active_candidate vss vdd row_drive sar_comparator_input
+ decision_p decision_n reset eval latch_sense_p_ext iso_tail_ext tail_ext vdd_ext
+ vss_escape_uq1 latch_sense_n_ext_uq1
Xphysical_preamp_n physical_preamp_n/source physical_preamp_n/drain physical_preamp_n/gate
+ vss_escape_uq1 preamp_n_nfet
Xphysical_preamp_p physical_preamp_p/source physical_preamp_p/drain physical_preamp_p/gate
+ vss_escape_uq1 preamp_p_nfet
Xconverter_latch_0 decision_p decision_n latch_sense_p_ext latch_sense_n_ext_uq1 tail_ext
+ reset vdd_ext vss_escape_uq1 eval row_drive sar_comparator_input iso_tail_ext vdd_ext
+ escaped_input_latch
C0 vss latch_sense_n_ext_uq1 0.23329f
C1 vdd_ext sar_readout_12b_0/vdd 1.39936f
C2 row_dac_10b_0/vdd row_dac_10b_0/vss 0.78467f
C3 iso_tail_ext sar_readout_12b_0/vdd 0.27521f
C4 vdd_ext sar_comparator_input 1.56594f
C5 shared_converter_mux_0/vss vdd_ext 0
C6 vdd_ext decision_p 0
C7 vdd_ext shared_converter_mux_0/mux_bus 0.00217f
C8 vdd_ext shared_converter_mux_0/vdd 0
C9 decision_n sar_comparator_input 0.27273f
C10 iso_tail_ext sar_comparator_input 0.05996f
C11 vdd_ext row_drive 3.96825f
C12 vdd_ext latch_sense_p_ext 3.83973f
C13 iso_tail_ext row_drive 2.13599f
C14 tail_ext decision_n 0.01085f
C15 iso_tail_ext latch_sense_p_ext -0.08311f
C16 reset tail_ext 0.01085f
C17 row_drive sar_readout_12b_0/vdd 0.58157f
C18 shared_converter_mux_0/vss shared_converter_mux_0/mux_bus 1.56188f
C19 vdd_ext sar_readout_12b_0/vss 0.93663f
C20 vdd_ext vss 0.19458f
C21 shared_converter_mux_0/vdd shared_converter_mux_0/mux_bus 1.55306f
C22 eval vdd_ext 0
C23 row_drive sar_comparator_input 5.41305f
C24 shared_converter_mux_0/vss row_drive 0.00246f
C25 iso_tail_ext sar_readout_12b_0/vss 0.60045f
C26 decision_p row_drive 0.02173f
C27 row_drive shared_converter_mux_0/mux_bus 0.06281f
C28 shared_converter_mux_0/vdd row_drive 0.00246f
C29 tail_ext sar_comparator_input 0.21605f
C30 latch_sense_p_ext sar_comparator_input 1.32953f
C31 tail_ext decision_p 0.01085f
C32 tail_ext row_drive 0.04474f
C33 latch_sense_p_ext row_drive 1.63035f
C34 sar_readout_12b_0/vss sar_readout_12b_0/vdd 0.49712f
C35 vss sar_comparator_input 0.09437f
C36 vdd_ext latch_sense_n_ext_uq1 3.48574f
C37 vss shared_converter_mux_0/mux_bus 0.03132f
C38 vss shared_converter_mux_0/vdd 0.2816f
C39 iso_tail_ext latch_sense_n_ext_uq1 -0.08311f
C40 row_dac_10b_0/vdd row_drive 1.11462f
C41 vdd_ext m1_68300_3080# 0.24419f
C42 sar_readout_12b_0/vss row_drive 0.29433f
C43 vss row_drive 0.44137f
C44 vss latch_sense_p_ext 0.32714f
C45 eval tail_ext 0.01085f
C46 latch_sense_n_ext_uq1 sar_comparator_input 0.15227f
C47 m1_68300_3080# sar_comparator_input 0.05195f
C48 row_drive latch_sense_n_ext_uq1 0.57894f
C49 latch_sense_p_ext latch_sense_n_ext_uq1 0.04014f
C50 m1_68300_3080# row_drive 2.68328f
C51 row_drive row_dac_10b_0/vss 1.08123f
C52 iso_tail_ext vdd_ext 0.86179f
C53 reset vdd_ext 0.01669f
C54 vdd row_drive 0.1964f
C55 vss vss_escape_uq1 36.6941f
C56 vdd vss_escape_uq1 36.7f
C57 latch_sense_p_ext vss_escape_uq1 0.65433f
C58 latch_sense_n_ext_uq1 vss_escape_uq1 -0.78417f
C59 m1_68300_3080# vss_escape_uq1 7.89552f **FLOATING
C60 iso_tail_ext vss_escape_uq1 -1.23816f
C61 sar_comparator_input vss_escape_uq1 15.6187f
C62 decision_n vss_escape_uq1 3.71824f
C63 eval vss_escape_uq1 0.78348f
C64 row_drive vss_escape_uq1 26.3069f
C65 vdd_ext vss_escape_uq1 45.73763f
.ends
