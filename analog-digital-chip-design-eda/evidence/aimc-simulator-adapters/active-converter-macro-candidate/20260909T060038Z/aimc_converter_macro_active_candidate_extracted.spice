* NGSPICE file created from aimc_converter_macro_active_candidate.ext - technology: sky130A

.subckt escaped_input_latch out_p out_n latch_sense_p latch_sense_n tail reset vdd
+ vss eval sense_p sense_n iso_tail vdd_active
X0 out_p out_n vdd_active vdd_active sky130_fd_pr__pfet_01v8 ad=6.72 pd=10.4 as=6.24 ps=10 w=2.4 l=0.6
X1 vdd reset out_n vdd sky130_fd_pr__pfet_01v8 ad=3.12 pd=7.6 as=3.36 ps=8 w=1.2 l=0.6
X2 tail out_p out_n vss sky130_fd_pr__nfet_01v8 ad=12.48 pd=14.8 as=13.44 ps=15.2 w=4.8 l=0.6
X3 out_p reset vdd vdd sky130_fd_pr__pfet_01v8 ad=3.36 pd=8 as=3.12 ps=7.6 w=1.2 l=0.6
X4 out_p out_n tail vss sky130_fd_pr__nfet_01v8 ad=13.44 pd=15.2 as=12.48 ps=14.8 w=4.8 l=0.6
X5 tail latch_sense_n out_n vss sky130_fd_pr__nfet_01v8 ad=12.48 pd=14.8 as=13.44 ps=15.2 w=4.8 l=0.6
X6 tail eval vss vss sky130_fd_pr__nfet_01v8 ad=16.2 pd=17.4 as=16.2 ps=17.4 w=6 l=0.6
X7 out_p latch_sense_p tail vss sky130_fd_pr__nfet_01v8 ad=13.44 pd=15.2 as=12.48 ps=14.8 w=4.8 l=0.6
X8 iso_tail sense_n latch_sense_n vss sky130_fd_pr__nfet_01v8 ad=3.12 pd=7.6 as=3.36 ps=8 w=1.2 l=0.6
X9 vdd_active out_p out_n vdd_active sky130_fd_pr__pfet_01v8 ad=6.24 pd=10 as=6.72 ps=10.4 w=2.4 l=0.6
X10 latch_sense_p sense_p iso_tail vss sky130_fd_pr__nfet_01v8 ad=3.36 pd=8 as=3.12 ps=7.6 w=1.2 l=0.6
C0 tail out_n 0.51868f
C1 out_p tail 0.51868f
C2 vdd out_n 0.77104f
C3 eval tail 0.29776f
C4 tail vdd_active 0.9938f
C5 out_p vdd 0.76206f
C6 iso_tail latch_sense_n 0.07366f
C7 out_p latch_sense_p 0.1874f
C8 out_p out_n 2.60132f
C9 out_n vdd_active 2.93626f
C10 out_p vdd_active 2.83065f
C11 sense_p latch_sense_p 0.02861f
C12 reset tail 0.16491f
C13 reset vdd 4.47121f
C14 reset out_n 0.31048f
C15 latch_sense_n tail 0.0334f
C16 iso_tail sense_n 0.10725f
C17 out_p reset 0.376f
C18 iso_tail latch_sense_p 0.07366f
C19 latch_sense_n sense_n 0.02861f
C20 latch_sense_n out_n 0.1874f
C21 iso_tail sense_p 0.10725f
C22 vdd tail 0.9918f
C23 tail latch_sense_p 0.0334f
C24 iso_tail vss 25.79857f
C25 latch_sense_n vss 1.99533f
C26 latch_sense_p vss 1.99533f
C27 out_n vss 10.5784f
C28 tail vss 79.29282f
C29 vdd_active vss 88.34975f
C30 vdd vss 78.65506f
.ends

.subckt aimc_converter_macro_active_candidate vss vdd row_drive sar_comparator_input
+ decision_p decision_n reset eval vss_escape vdd_uq0
Xconverter_latch_0 decision_p decision_n converter_latch_0/latch_sense_p converter_latch_0/latch_sense_n
+ converter_latch_0/tail reset vdd_uq0 vss_escape eval row_drive sar_comparator_input
+ converter_latch_0/iso_tail vdd_uq0 escaped_input_latch
C0 vdd_uq0 shared_converter_mux_0/vss 0
C1 shared_converter_mux_0/vdd shared_converter_mux_0/mux_bus 1.55306f
C2 sar_readout_12b_0/vss converter_latch_0/iso_tail 0.60149f
C3 converter_latch_0/iso_tail row_drive 0.26293f
C4 sar_readout_12b_0/vss sar_readout_12b_0/vdd 0.49712f
C5 sar_readout_12b_0/vdd row_drive 0.33461f
C6 row_dac_10b_0/vdd row_drive 1.11409f
C7 row_drive shared_converter_mux_0/mux_bus 0.06281f
C8 shared_converter_mux_0/vdd row_drive 0.00246f
C9 converter_latch_0/latch_sense_p vss 0.23329f
C10 sar_readout_12b_0/vss row_drive 0.21493f
C11 converter_latch_0/latch_sense_n vss 0.23329f
C12 shared_converter_mux_0/mux_bus vss 0.03132f
C13 vdd_uq0 converter_latch_0/iso_tail 0.31557f
C14 eval converter_latch_0/tail 0.01085f
C15 vdd_uq0 sar_readout_12b_0/vdd 1.39936f
C16 shared_converter_mux_0/vdd vss 0.2816f
C17 vdd_uq0 shared_converter_mux_0/mux_bus 0.00217f
C18 vdd_uq0 eval 0
C19 row_drive vss 0.22445f
C20 vdd_uq0 shared_converter_mux_0/vdd 0
C21 shared_converter_mux_0/vss shared_converter_mux_0/mux_bus 1.56188f
C22 vdd row_drive 0.1964f
C23 sar_comparator_input converter_latch_0/iso_tail 0.08712f
C24 sar_readout_12b_0/vss vdd_uq0 0.93663f
C25 vdd_uq0 row_drive 1.55835f
C26 decision_p converter_latch_0/tail 0.01085f
C27 shared_converter_mux_0/vss row_drive 0.00246f
C28 vdd_uq0 decision_p 0
C29 decision_n converter_latch_0/tail 0.01085f
C30 row_dac_10b_0/vss row_dac_10b_0/vdd 0.78467f
C31 converter_latch_0/tail reset 0.01085f
C32 vdd_uq0 reset 0.01669f
C33 sar_readout_12b_0/vdd converter_latch_0/iso_tail 0.27625f
C34 row_dac_10b_0/vss row_drive 1.08123f
C35 vdd_uq0 vss 0.19458f
C36 vss vss_escape 30.5941f
C37 vdd vss_escape 30.5941f
C38 sar_comparator_input vss_escape 0.93057f
C39 decision_n vss_escape 3.8093f
C40 row_drive vss_escape 6.8802f
C41 vdd_uq0 vss_escape 34.16415f
.ends
