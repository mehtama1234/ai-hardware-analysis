* NGSPICE file created from aimc_converter_macro_active_candidate_flat.ext - technology: sky130A

.subckt aimc_converter_macro_active_candidate_flat vss vdd row_drive decision_p decision_n
+ reset eval vss_escape latch_sense_p_ext latch_sense_n_ext iso_tail_ext tail_ext
+ vdd_ext
X0 physical_preamp_0.preamp_iso_tail_ext vdd_ext vdd_ext vss_escape sky130_fd_pr__nfet_01v8 ad=3.12 pd=7.6 as=3.36 ps=8 w=1.2 l=0.6
X1 vdd_ext decision_p decision_n vdd_ext sky130_fd_pr__pfet_01v8 ad=3.12 pd=7.6 as=3.36 ps=8 w=1.2 l=0.6
X2 tail_ext eval vss_escape vss_escape sky130_fd_pr__nfet_01v8 ad=16.2 pd=17.4 as=16.2 ps=17.4 w=6 l=0.6
X3 vdd_ext row_drive physical_preamp_0.preamp_iso_tail_ext vss_escape sky130_fd_pr__nfet_01v8 ad=3.36 pd=8 as=3.12 ps=7.6 w=1.2 l=0.6
X4 decision_p latch_sense_p_ext tail_ext vss_escape sky130_fd_pr__nfet_01v8 ad=3.36 pd=8 as=3.12 ps=7.6 w=1.2 l=0.6
X5 vdd_ext reset decision_n vdd_ext sky130_fd_pr__pfet_01v8 ad=3.12 pd=7.6 as=3.36 ps=8 w=1.2 l=0.6
X6 tail_ext latch_sense_n_ext decision_n vss_escape sky130_fd_pr__nfet_01v8 ad=3.12 pd=7.6 as=3.36 ps=8 w=1.2 l=0.6
X7 decision_p decision_n vdd_ext vdd_ext sky130_fd_pr__pfet_01v8 ad=3.36 pd=8 as=3.12 ps=7.6 w=1.2 l=0.6
X8 tail_ext decision_p decision_n vss_escape sky130_fd_pr__nfet_01v8 ad=3.12 pd=7.6 as=3.36 ps=8 w=1.2 l=0.6
X9 latch_sense_p_ext row_drive iso_tail_ext vss_escape sky130_fd_pr__nfet_01v8 ad=3.36 pd=8 as=3.12 ps=7.6 w=1.2 l=0.6
X10 iso_tail_ext vdd_ext latch_sense_n_ext vss_escape sky130_fd_pr__nfet_01v8 ad=3.12 pd=7.6 as=3.36 ps=8 w=1.2 l=0.6
X11 decision_p reset vdd_ext vdd_ext sky130_fd_pr__pfet_01v8 ad=3.36 pd=8 as=3.12 ps=7.6 w=1.2 l=0.6
X12 decision_p decision_n tail_ext vss_escape sky130_fd_pr__nfet_01v8 ad=3.36 pd=8 as=3.12 ps=7.6 w=1.2 l=0.6
C0 row_drive sar_readout_12b_0.vdd 0.58157f
C1 row_drive sar_readout_12b_0.vss 0.29433f
C2 latch_sense_n_ext iso_tail_ext 0.12577f
C3 row_drive iso_tail_ext 2.39704f
C4 vdd_ext m1_68300_3080# 0.24527f
C5 shared_converter_mux_0.vdd vss 0.2816f
C6 physical_preamp_0.preamp_iso_tail_ext m1_68300_3080# 0.01748f
C7 reset decision_n 0.31048f
C8 vdd_ext shared_converter_mux_0.mux_bus 0.00217f
C9 vdd_ext tail_ext 1.9856f
C10 sar_readout_12b_0.vdd sar_readout_12b_0.vss 0.49712f
C11 latch_sense_p_ext tail_ext 0.0334f
C12 vdd_ext latch_sense_n_ext 3.52723f
C13 row_drive vdd 0.1964f
C14 row_drive vdd_ext 11.8495f
C15 m2_64900_1400# m1_68300_3080# 0
C16 physical_preamp_0.preamp_iso_tail_ext row_drive 0.35829f
C17 vdd_ext decision_p 3.8282f
C18 row_drive latch_sense_p_ext 0.6214f
C19 iso_tail_ext sar_readout_12b_0.vdd 0.27521f
C20 iso_tail_ext sar_readout_12b_0.vss 0.60045f
C21 latch_sense_p_ext decision_p 0.18428f
C22 vdd_ext eval 0
C23 vdd_ext shared_converter_mux_0.vdd 0
C24 row_drive row_dac_10b_0.vdd 1.11462f
C25 reset tail_ext 0.17577f
C26 row_dac_10b_0.vss row_drive 1.08123f
C27 row_drive m2_64900_1400# 0.04869f
C28 vdd_ext vss 0.19458f
C29 shared_converter_mux_0.mux_bus shared_converter_mux_0.vss 1.56188f
C30 vdd_ext sar_readout_12b_0.vdd 1.39936f
C31 vdd_ext sar_readout_12b_0.vss 0.93663f
C32 latch_sense_p_ext vss 0.23329f
C33 reset decision_p 0.376f
C34 row_drive shared_converter_mux_0.vss 0.00246f
C35 vdd_ext iso_tail_ext 1.029f
C36 iso_tail_ext latch_sense_p_ext 0.12577f
C37 tail_ext decision_n 0.48065f
C38 latch_sense_n_ext decision_n 0.18428f
C39 decision_p decision_n 2.54301f
C40 physical_preamp_0.preamp_iso_tail_ext vdd_ext 0.57172f
C41 vdd_ext latch_sense_p_ext 3.43095f
C42 row_drive m1_68300_3080# 2.68356f
C43 vdd_ext m2_64900_1400# 1.21414f
C44 physical_preamp_0.preamp_iso_tail_ext m2_64900_1400# 0.34303f
C45 vdd_ext reset 4.48789f
C46 vdd_ext shared_converter_mux_0.vss 0
C47 latch_sense_n_ext tail_ext 0.0334f
C48 row_drive shared_converter_mux_0.mux_bus 0.06281f
C49 row_dac_10b_0.vss row_dac_10b_0.vdd 0.78467f
C50 tail_ext decision_p 0.48065f
C51 row_drive latch_sense_n_ext 0.57746f
C52 tail_ext eval 0.36751f
C53 shared_converter_mux_0.vdd shared_converter_mux_0.mux_bus 1.55306f
C54 vdd_ext decision_n 3.9382f
C55 row_drive shared_converter_mux_0.vdd 0.00246f
C56 shared_converter_mux_0.mux_bus vss 0.03132f
C57 latch_sense_n_ext vss 0.23329f
C58 row_drive vss 0.22445f
C59 vss vss_escape 36.2292f
C60 vdd vss_escape 36.7f
C61 iso_tail_ext vss_escape 60.58279f
C62 latch_sense_n_ext vss_escape 39.61459f
C63 decision_p vss_escape 7.38983f
C64 tail_ext vss_escape 81.08725f
C65 m2_64900_1400# vss_escape 0.69005f ; **FLOATING
C66 sar_readout_12b_0.vss vss_escape 1.33686f ; **FLOATING
C67 row_dac_10b_0.vss vss_escape 1.40333f ; **FLOATING
C68 row_dac_10b_0.vdd vss_escape 1.33457f ; **FLOATING
C69 sar_readout_12b_0.vdd vss_escape 1.77614f ; **FLOATING
C70 m1_68300_3080# vss_escape 7.90194f ; **FLOATING
C71 shared_converter_mux_0.vss vss_escape 1.39454f ; **FLOATING
C72 shared_converter_mux_0.mux_bus vss_escape 2.86922f ; **FLOATING
C73 shared_converter_mux_0.vdd vss_escape 0.95985f ; **FLOATING
C74 physical_preamp_0.preamp_iso_tail_ext vss_escape 0.15923p
.ends
