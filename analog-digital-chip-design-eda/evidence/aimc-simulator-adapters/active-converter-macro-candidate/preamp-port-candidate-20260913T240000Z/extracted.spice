* NGSPICE file created from preamp_port_candidate.ext - technology: sky130A

.subckt preamp_port_candidate preamp_iso_tail_ext latch_sense_p_ext latch_sense_n_ext
+ row_drive sar_comparator_input vss_escape
X0 preamp_iso_tail_ext sar_comparator_input latch_sense_n_ext a_2000_3600# sky130_fd_pr__nfet_01v8 ad=3.12 pd=7.6 as=3.36 ps=8 w=1.2 l=0.6
X1 latch_sense_p_ext row_drive preamp_iso_tail_ext a_2000_3600# sky130_fd_pr__nfet_01v8 ad=3.36 pd=8 as=3.12 ps=7.6 w=1.2 l=0.6
C0 latch_sense_n_ext latch_sense_p_ext 0.00782f
C1 m1_3440_500# sar_comparator_input 0.04555f
C2 preamp_iso_tail_ext sar_comparator_input 0.11179f
C3 m2_900_1400# sar_comparator_input 0.04273f
C4 m1_3440_500# preamp_iso_tail_ext 0.0015f
C5 m2_900_1400# m1_3440_500# 0.01113f
C6 m2_900_1400# preamp_iso_tail_ext 0.34398f
C7 preamp_iso_tail_ext row_drive 0.12292f
C8 latch_sense_p_ext preamp_iso_tail_ext 0.05749f
C9 m2_900_1400# row_drive 0.04273f
C10 latch_sense_p_ext m2_900_1400# 0.41846f
C11 latch_sense_n_ext sar_comparator_input 0.02157f
C12 latch_sense_p_ext row_drive 0.02157f
C13 vss_escape preamp_iso_tail_ext 0.00704f
C14 m1_1000_500# preamp_iso_tail_ext 0.0015f
C15 latch_sense_n_ext m1_3440_500# 0.0015f
C16 m2_900_1400# m1_1000_500# 0.01113f
C17 latch_sense_n_ext preamp_iso_tail_ext 0.05717f
C18 m1_1000_500# row_drive 0.04555f
C19 latch_sense_p_ext m1_1000_500# 0.0015f
C20 latch_sense_n_ext m2_900_1400# 0.41846f
C21 vss_escape a_2000_3600# 0.38483f
C22 latch_sense_n_ext a_2000_3600# 1.04634f
C23 latch_sense_p_ext a_2000_3600# 1.04634f
C24 preamp_iso_tail_ext a_2000_3600# 4.22663f
C25 m2_900_1400# a_2000_3600# 1.01648f ; **FLOATING
C26 m1_3440_500# a_2000_3600# 0.31893f ; **FLOATING
C27 m1_1000_500# a_2000_3600# 0.31893f ; **FLOATING
.ends
