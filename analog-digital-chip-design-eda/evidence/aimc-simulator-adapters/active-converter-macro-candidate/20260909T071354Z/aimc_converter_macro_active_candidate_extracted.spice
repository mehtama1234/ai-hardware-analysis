* NGSPICE file created from aimc_converter_macro_active_candidate.ext - technology: sky130A

.subckt sky130_transistor_active_isolation_pair iso_tail iso_p iso_n sense_p sense_n
+ m1_3440_500# m1_1000_500# m2_900_1400# VSUBS
X0 iso_tail sense_n iso_n VSUBS sky130_fd_pr__nfet_01v8 ad=3.12 pd=7.6 as=3.36 ps=8 w=1.2 l=0.6
X1 iso_p sense_p iso_tail VSUBS sky130_fd_pr__nfet_01v8 ad=3.36 pd=8 as=3.12 ps=7.6 w=1.2 l=0.6
C0 m1_1000_500# sense_p 0.04555f
C1 sense_p iso_p 0.02157f
C2 sense_n m1_3440_500# 0.04555f
C3 m1_3440_500# m2_900_1400# 0.01113f
C4 m1_1000_500# iso_p 0.0015f
C5 iso_p iso_n 0.00782f
C6 sense_n iso_tail 0.11179f
C7 m2_900_1400# iso_tail 0.34398f
C8 sense_p m2_900_1400# 0.04273f
C9 m1_3440_500# iso_tail 0.0015f
C10 sense_n iso_n 0.02157f
C11 m1_1000_500# m2_900_1400# 0.01113f
C12 m2_900_1400# iso_n 0.41846f
C13 iso_p m2_900_1400# 0.41846f
C14 sense_p iso_tail 0.12292f
C15 m1_3440_500# iso_n 0.0015f
C16 m1_1000_500# iso_tail 0.0015f
C17 iso_n iso_tail 0.05717f
C18 iso_p iso_tail 0.05749f
C19 sense_n m2_900_1400# 0.04273f
C20 iso_n VSUBS 1.04634f
C21 iso_p VSUBS 1.04634f
C22 iso_tail VSUBS 4.24257f
C23 m2_900_1400# VSUBS 1.01648f
C24 m1_3440_500# VSUBS 0.31893f
C25 m1_1000_500# VSUBS 0.31893f
.ends

.subckt escaped_input_latch out_p out_n latch_sense_p latch_sense_n tail reset vdd
+ vss eval sense_p sense_n iso_tail vdd_active
X0 out_p out_n vdd_active vdd_active sky130_fd_pr__pfet_01v8 ad=3.36 pd=8 as=3.12 ps=7.6 w=1.2 l=0.6
X1 vdd reset out_n vdd sky130_fd_pr__pfet_01v8 ad=3.12 pd=7.6 as=3.36 ps=8 w=1.2 l=0.6
X2 tail out_p out_n vss sky130_fd_pr__nfet_01v8 ad=3.12 pd=7.6 as=3.36 ps=8 w=1.2 l=0.6
X3 out_p reset vdd vdd sky130_fd_pr__pfet_01v8 ad=3.36 pd=8 as=3.12 ps=7.6 w=1.2 l=0.6
X4 out_p out_n tail vss sky130_fd_pr__nfet_01v8 ad=3.36 pd=8 as=3.12 ps=7.6 w=1.2 l=0.6
X5 tail latch_sense_n out_n vss sky130_fd_pr__nfet_01v8 ad=3.12 pd=7.6 as=3.36 ps=8 w=1.2 l=0.6
X6 tail eval vss vss sky130_fd_pr__nfet_01v8 ad=16.2 pd=17.4 as=16.2 ps=17.4 w=6 l=0.6
X7 out_p latch_sense_p tail vss sky130_fd_pr__nfet_01v8 ad=3.36 pd=8 as=3.12 ps=7.6 w=1.2 l=0.6
X8 iso_tail sense_n latch_sense_n vss sky130_fd_pr__nfet_01v8 ad=3.12 pd=7.6 as=3.36 ps=8 w=1.2 l=0.6
X9 vdd_active out_p out_n vdd_active sky130_fd_pr__pfet_01v8 ad=3.12 pd=7.6 as=3.36 ps=8 w=1.2 l=0.6
X10 latch_sense_p sense_p iso_tail vss sky130_fd_pr__nfet_01v8 ad=3.36 pd=8 as=3.12 ps=7.6 w=1.2 l=0.6
C0 out_n vdd_active 3.16716f
C1 vdd_active out_p 3.06556f
C2 iso_tail latch_sense_n 0.20888f
C3 out_n latch_sense_n 0.18428f
C4 out_n out_p 2.54301f
C5 out_n reset 0.31048f
C6 reset out_p 0.376f
C7 eval tail 0.35666f
C8 vdd tail 0.9918f
C9 latch_sense_p tail 0.0334f
C10 iso_tail sense_n 0.10725f
C11 sense_n latch_sense_n 0.22977f
C12 sense_p latch_sense_p 0.22977f
C13 iso_tail latch_sense_p 0.20888f
C14 out_n vdd 0.77104f
C15 vdd out_p 0.76206f
C16 reset vdd 4.47121f
C17 vdd_active tail 0.9938f
C18 latch_sense_p out_p 0.18428f
C19 latch_sense_n tail 0.0334f
C20 out_n tail 0.46979f
C21 iso_tail sense_p 0.26105f
C22 out_p tail 0.46979f
C23 reset tail 0.16491f
C24 iso_tail vss 29.23796f
C25 latch_sense_n vss 1.7693f
C26 latch_sense_p vss 1.56796f
C27 out_n vss 13.58747f
C28 tail vss 89.03816f
C29 vdd_active vss 90.11912f
C30 vdd vss 78.65506f
.ends

.subckt aimc_converter_macro_active_candidate vss vdd row_drive sar_comparator_input
+ decision_p decision_n reset eval vss_escape latch_sense_p_ext latch_sense_n_ext
+ iso_tail_ext tail_ext vdd_ext preamp_iso_tail_ext
Xphysical_preamp_0 physical_preamp_0/iso_tail physical_preamp_0/iso_p physical_preamp_0/iso_n
+ physical_preamp_0/sense_p physical_preamp_0/sense_n sar_comparator_input row_drive
+ physical_preamp_0/m2_900_1400# vss_escape sky130_transistor_active_isolation_pair
Xconverter_latch_0 decision_p decision_n latch_sense_p_ext latch_sense_n_ext tail_ext
+ reset vdd_ext vss_escape eval row_drive sar_comparator_input iso_tail_ext vdd_ext
+ escaped_input_latch
C0 shared_converter_mux_0/vdd row_drive 0.00246f
C1 vdd_ext decision_p 0
C2 row_drive sar_readout_12b_0/vss 0.29422f
C3 vss latch_sense_p_ext 0.23329f
C4 m5_31940_4400# vss 0.79275f
C5 vdd_ext m1_65540_3540# 0.16749f
C6 row_drive physical_preamp_0/iso_p -0
C7 row_drive sar_comparator_input 5.23145f
C8 decision_p tail_ext 0.01085f
C9 vdd_ext shared_converter_mux_0/vss 0
C10 physical_preamp_0/sense_p sar_comparator_input 0.04049f
C11 iso_tail_ext latch_sense_n_ext 0.0023f
C12 physical_preamp_0/iso_n sar_comparator_input 0.027f
C13 vdd_ext reset 0.01669f
C14 shared_converter_mux_0/vdd vdd_ext 0
C15 vdd_ext sar_readout_12b_0/vss 0.93663f
C16 physical_preamp_0/sense_n sar_comparator_input 0.02993f
C17 m1_65540_3540# sar_comparator_input 0.00201f
C18 latch_sense_p_ext iso_tail_ext 0.00407f
C19 row_drive sar_readout_12b_0/vdd 0.57218f
C20 row_drive vss 0.22445f
C21 physical_preamp_0/iso_tail row_drive 0.02329f
C22 decision_n tail_ext 0.01085f
C23 row_drive physical_preamp_0/m2_900_1400# -0.00731f
C24 tail_ext reset 0.01085f
C25 vdd_ext sar_comparator_input 0.06859f
C26 physical_preamp_0/m2_900_1400# physical_preamp_0/sense_p -0.00637f
C27 physical_preamp_0/m2_900_1400# physical_preamp_0/iso_n -0
C28 m1_65540_3540# vss 0.34353f
C29 row_dac_10b_0/vdd row_dac_10b_0/vss 0.78467f
C30 physical_preamp_0/iso_tail m1_65540_3540# 0.01386f
C31 m1_65540_3540# m1_67140_3540# 0.01594f
C32 physical_preamp_0/sense_n physical_preamp_0/m2_900_1400# -0.00318f
C33 row_drive row_dac_10b_0/vdd 1.11462f
C34 vdd_ext sar_readout_12b_0/vdd 1.39936f
C35 vdd_ext vss 0.19458f
C36 physical_preamp_0/iso_p sar_comparator_input 0.02717f
C37 row_drive iso_tail_ext 1.71857f
C38 row_drive latch_sense_n_ext 0.22052f
C39 row_drive shared_converter_mux_0/mux_bus 0.06281f
C40 shared_converter_mux_0/vdd vss 0.2816f
C41 m1_69940_2940# preamp_iso_tail_ext 0.03103f
C42 sar_readout_12b_0/vdd sar_readout_12b_0/vss 0.49712f
C43 row_drive latch_sense_p_ext 0.22267f
C44 m1_65540_3540# latch_sense_n_ext 0.07314f
C45 physical_preamp_0/iso_tail sar_comparator_input 0.0361f
C46 physical_preamp_0/m2_900_1400# physical_preamp_0/iso_p 0
C47 physical_preamp_0/m2_900_1400# sar_comparator_input 0.16477f
C48 m1_65540_3540# latch_sense_p_ext 0.0673f
C49 vdd_ext iso_tail_ext 0.3078f
C50 vdd_ext shared_converter_mux_0/mux_bus 0.00217f
C51 shared_converter_mux_0/mux_bus shared_converter_mux_0/vss 1.56188f
C52 m1_65540_3540# m5_31940_4400# 3.35237f
C53 row_drive row_dac_10b_0/vss 1.08123f
C54 shared_converter_mux_0/vdd shared_converter_mux_0/mux_bus 1.55306f
C55 sar_readout_12b_0/vss iso_tail_ext 0.60045f
C56 vdd_ext m5_31940_4400# 0.16749f
C57 vss m1_67140_3540# 0.00501f
C58 physical_preamp_0/iso_tail m1_67140_3540# 0.00501f
C59 vdd_ext eval 0
C60 row_drive physical_preamp_0/sense_p 0.03836f
C61 sar_comparator_input iso_tail_ext 0.05996f
C62 sar_comparator_input latch_sense_n_ext 0
C63 row_drive vdd 0.1964f
C64 row_drive m1_65540_3540# 0.00201f
C65 eval tail_ext 0.01085f
C66 m1_65540_3540# physical_preamp_0/sense_p 0.00135f
C67 vdd_ext row_drive 2.1538f
C68 row_drive shared_converter_mux_0/vss 0.00246f
C69 sar_readout_12b_0/vdd iso_tail_ext 0.27521f
C70 vss latch_sense_n_ext 0.23329f
C71 shared_converter_mux_0/mux_bus vss 0.03132f
C72 preamp_iso_tail_ext vss_escape 0.18641f
C73 vss vss_escape 36.6898f
C74 vdd vss_escape 36.7f
C75 m5_31940_4400# vss_escape 9.09477f ; **FLOATING
C76 m1_69940_2940# vss_escape 0.19727f ; **FLOATING
C77 m1_67140_3540# vss_escape 0.41976f ; **FLOATING
C78 m1_65540_3540# vss_escape 18.8295f ; **FLOATING
C79 iso_tail_ext vss_escape -1.05232f
C80 sar_comparator_input vss_escape 10.66696f
C81 latch_sense_n_ext vss_escape -0.27849f
C82 latch_sense_p_ext vss_escape -0.37707f
C83 decision_n vss_escape 3.8093f
C84 eval vss_escape 0.78348f
C85 row_drive vss_escape 19.1176f
C86 vdd_ext vss_escape 34.08534f
.ends
