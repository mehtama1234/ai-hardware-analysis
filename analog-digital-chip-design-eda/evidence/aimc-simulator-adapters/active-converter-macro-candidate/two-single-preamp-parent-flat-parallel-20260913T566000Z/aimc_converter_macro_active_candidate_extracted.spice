* NGSPICE file created from aimc_converter_macro_active_candidate_flat_parallel.ext - technology: sky130A

.subckt aimc_converter_macro_active_candidate_flat_parallel vss vdd row_drive sar_comparator_input
+ decision_p decision_n reset eval vss_escape latch_sense_p_ext latch_sense_n_ext
+ iso_tail_ext tail_ext vdd_ext preamp_iso_tail_ext
X0 latch_sense_n_ext a_51120_36400# preamp_iso_tail_ext vss_escape sky130_fd_pr__nfet_01v8 ad=3.36 pd=8 as=3.12 ps=7.6 w=1.2 l=0.6
X1 latch_sense_p_ext a_46720_36400# preamp_iso_tail_ext vss_escape sky130_fd_pr__nfet_01v8 ad=3.36 pd=8 as=3.12 ps=7.6 w=1.2 l=0.6
X2 vdd_ext decision_p decision_n vdd_ext sky130_fd_pr__pfet_01v8 ad=3.12 pd=7.6 as=3.36 ps=8 w=1.2 l=0.6
X3 tail_ext eval vss_escape vss_escape sky130_fd_pr__nfet_01v8 ad=16.2 pd=17.4 as=16.2 ps=17.4 w=6 l=0.6
X4 latch_sense_n_ext a_52720_36400# preamp_iso_tail_ext vss_escape sky130_fd_pr__nfet_01v8 ad=3.36 pd=8 as=3.12 ps=7.6 w=1.2 l=0.6
X5 decision_p latch_sense_p_ext tail_ext vss_escape sky130_fd_pr__nfet_01v8 ad=3.36 pd=8 as=3.12 ps=7.6 w=1.2 l=0.6
X6 vdd_ext reset decision_n vdd_ext sky130_fd_pr__pfet_01v8 ad=3.12 pd=7.6 as=3.36 ps=8 w=1.2 l=0.6
X7 tail_ext latch_sense_n_ext decision_n vss_escape sky130_fd_pr__nfet_01v8 ad=3.12 pd=7.6 as=3.36 ps=8 w=1.2 l=0.6
X8 decision_p decision_n vdd_ext vdd_ext sky130_fd_pr__pfet_01v8 ad=3.36 pd=8 as=3.12 ps=7.6 w=1.2 l=0.6
X9 tail_ext decision_p decision_n vss_escape sky130_fd_pr__nfet_01v8 ad=3.12 pd=7.6 as=3.36 ps=8 w=1.2 l=0.6
X10 latch_sense_p_ext row_drive iso_tail_ext vss_escape sky130_fd_pr__nfet_01v8 ad=3.36 pd=8 as=3.12 ps=7.6 w=1.2 l=0.6
X11 iso_tail_ext sar_comparator_input latch_sense_n_ext vss_escape sky130_fd_pr__nfet_01v8 ad=3.12 pd=7.6 as=3.36 ps=8 w=1.2 l=0.6
X12 latch_sense_p_ext a_45120_36400# preamp_iso_tail_ext vss_escape sky130_fd_pr__nfet_01v8 ad=3.36 pd=8 as=3.12 ps=7.6 w=1.2 l=0.6
X13 decision_p reset vdd_ext vdd_ext sky130_fd_pr__pfet_01v8 ad=3.36 pd=8 as=3.12 ps=7.6 w=1.2 l=0.6
X14 decision_p decision_n tail_ext vss_escape sky130_fd_pr__nfet_01v8 ad=3.36 pd=8 as=3.12 ps=7.6 w=1.2 l=0.6
C0 vss vdd_ext 0.19458f
C1 a_46720_36400# vdd_ext 0.00945f
C2 sar_readout_12b_0.vss iso_tail_ext 0.60045f
C3 shared_converter_mux_0.mux_bus vdd_ext 0.00217f
C4 a_51120_36400# preamp_iso_tail_ext 0.1436f
C5 sar_readout_12b_0.vss vdd_ext 0.93663f
C6 a_45120_36400# latch_sense_n_ext 0.01895f
C7 vdd_ext m1_68300_3080# 0.24419f
C8 row_drive latch_sense_p_ext 1.28502f
C9 latch_sense_p_ext m4_32000_38940# 0.00354f
C10 iso_tail_ext latch_sense_n_ext 0.12999f
C11 decision_p tail_ext 0.48065f
C12 a_45120_36400# m4_45060_36440# 0.00936f
C13 shared_converter_mux_0.vdd vdd_ext 0
C14 a_45120_36400# vdd_ext 0.00411f
C15 latch_sense_n_ext vdd_ext 4.56493f
C16 iso_tail_ext vdd_ext 0.86179f
C17 decision_n decision_p 2.54301f
C18 vss row_drive 0.22445f
C19 a_46720_36400# row_drive 0.12191f
C20 decision_n sar_comparator_input 0.17131f
C21 vdd_ext m4_45060_36440# 0.01404f
C22 shared_converter_mux_0.mux_bus row_drive 0.06281f
C23 vdd row_drive 0.1964f
C24 decision_p latch_sense_p_ext 0.37635f
C25 reset vdd_ext 4.48789f
C26 row_dac_10b_0.vss row_drive 1.08123f
C27 sar_comparator_input latch_sense_p_ext 0.11023f
C28 sar_readout_12b_0.vss row_drive 0.29433f
C29 row_drive m1_68300_3080# 2.68328f
C30 row_dac_10b_0.vss row_dac_10b_0.vdd 0.78467f
C31 vdd_ext eval 0
C32 latch_sense_p_ext preamp_iso_tail_ext 0.65876f
C33 shared_converter_mux_0.vdd row_drive 0.00246f
C34 a_45120_36400# row_drive 0.14304f
C35 latch_sense_n_ext row_drive 0.79988f
C36 vss sar_comparator_input 0.05708f
C37 latch_sense_n_ext m4_32000_38940# 0.0096f
C38 sar_comparator_input a_46720_36400# 0.0189f
C39 a_52720_36400# latch_sense_n_ext 0.08882f
C40 iso_tail_ext row_drive 2.39704f
C41 shared_converter_mux_0.vss shared_converter_mux_0.mux_bus 1.56188f
C42 row_drive m4_45060_36440# 0.09834f
C43 a_46720_36400# preamp_iso_tail_ext 0.05066f
C44 row_drive vdd_ext 5.0814f
C45 decision_n tail_ext 0.48065f
C46 sar_comparator_input m1_68300_3080# 0.05195f
C47 a_52720_36400# vdd_ext 0.00945f
C48 tail_ext latch_sense_p_ext 0.99589f
C49 m2_42000_41940# row_drive 0.12051f
C50 a_45120_36400# sar_comparator_input 0.01601f
C51 sar_comparator_input latch_sense_n_ext 0.64585f
C52 iso_tail_ext sar_comparator_input 0.16721f
C53 a_45120_36400# preamp_iso_tail_ext 0.15424f
C54 latch_sense_n_ext preamp_iso_tail_ext 0.66393f
C55 decision_p vdd_ext 3.8282f
C56 sar_comparator_input m4_45060_36440# 0.05954f
C57 decision_p reset 0.376f
C58 latch_sense_n_ext a_51120_36400# 0.07662f
C59 sar_comparator_input vdd_ext 1.76819f
C60 shared_converter_mux_0.vss vdd_ext 0
C61 preamp_iso_tail_ext m4_45060_36440# 0.00188f
C62 vdd_ext preamp_iso_tail_ext 0.06069f
C63 sar_readout_12b_0.vss sar_readout_12b_0.vdd 0.49712f
C64 a_51120_36400# vdd_ext 0.00487f
C65 row_dac_10b_0.vdd row_drive 1.11462f
C66 vss latch_sense_p_ext 0.29037f
C67 a_46720_36400# latch_sense_p_ext 0.06268f
C68 latch_sense_n_ext tail_ext 1.09601f
C69 iso_tail_ext sar_readout_12b_0.vdd 0.27521f
C70 sar_comparator_input row_drive 5.5001f
C71 a_52720_36400# sar_comparator_input 0.123f
C72 vdd_ext sar_readout_12b_0.vdd 1.39936f
C73 shared_converter_mux_0.vss row_drive 0.00246f
C74 decision_n latch_sense_n_ext 0.37635f
C75 tail_ext vdd_ext 1.9856f
C76 vss shared_converter_mux_0.mux_bus 0.03132f
C77 reset tail_ext 0.17577f
C78 row_drive preamp_iso_tail_ext 0.05458f
C79 a_52720_36400# preamp_iso_tail_ext 0.04002f
C80 a_45120_36400# latch_sense_p_ext 0.07133f
C81 latch_sense_n_ext latch_sense_p_ext 0.69337f
C82 a_52720_36400# a_51120_36400# 0.01036f
C83 tail_ext eval 0.36751f
C84 decision_n vdd_ext 3.9382f
C85 iso_tail_ext latch_sense_p_ext 0.1295f
C86 decision_n reset 0.31048f
C87 latch_sense_p_ext m4_45060_36440# 0.00631f
C88 vdd_ext latch_sense_p_ext 5.39204f
C89 vss shared_converter_mux_0.vdd 0.2816f
C90 reset latch_sense_p_ext 0.19529f
C91 vss latch_sense_n_ext 0.29037f
C92 shared_converter_mux_0.mux_bus shared_converter_mux_0.vdd 1.55306f
C93 a_45120_36400# a_46720_36400# 0.01036f
C94 latch_sense_n_ext a_46720_36400# 0.02118f
C95 sar_comparator_input preamp_iso_tail_ext 0.14481f
C96 latch_sense_p_ext eval 0.19752f
C97 row_drive sar_readout_12b_0.vdd 0.58157f
C98 sar_comparator_input a_51120_36400# 0.16277f
C99 a_46720_36400# m4_45060_36440# 0
C100 vss vss_escape 36.2394f
C101 vdd vss_escape 36.7f
C102 iso_tail_ext vss_escape 93.51715f
C103 decision_p vss_escape 12.48503f
C104 tail_ext vss_escape 0.1231p
C105 latch_sense_n_ext vss_escape 18.07895f
C106 latch_sense_p_ext vss_escape 55.2892f
C107 preamp_iso_tail_ext vss_escape 9.83002f
C108 vdd_ext vss_escape 0.25966p
C109 m4_45060_36440# vss_escape 0.07671f ; **FLOATING
C110 m4_32000_38940# vss_escape 0.1568f ; **FLOATING
C111 m2_42000_41940# vss_escape 3.91591f ; **FLOATING
C112 sar_readout_12b_0.vss vss_escape 1.33686f ; **FLOATING
C113 row_dac_10b_0.vss vss_escape 1.40333f ; **FLOATING
C114 row_dac_10b_0.vdd vss_escape 1.33457f ; **FLOATING
C115 sar_readout_12b_0.vdd vss_escape 1.77614f ; **FLOATING
C116 m1_68300_3080# vss_escape 7.89552f ; **FLOATING
C117 shared_converter_mux_0.vss vss_escape 1.39454f ; **FLOATING
C118 shared_converter_mux_0.mux_bus vss_escape 2.86922f ; **FLOATING
C119 shared_converter_mux_0.vdd vss_escape 0.95985f ; **FLOATING
.ends
