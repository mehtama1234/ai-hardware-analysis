* NGSPICE file created from aimc_converter_macro_active_candidate.ext - technology: sky130A

.subckt sky130_transistor_active_isolation_pair iso_tail iso_p iso_n sense_p sense_n
+ m1_3440_500# m1_1000_500# m2_900_1400# VSUBS
X0 iso_tail sense_n iso_n VSUBS sky130_fd_pr__nfet_01v8 ad=3.12 pd=7.6 as=3.36 ps=8 w=1.2 l=0.6
X1 iso_p sense_p iso_tail VSUBS sky130_fd_pr__nfet_01v8 ad=3.36 pd=8 as=3.12 ps=7.6 w=1.2 l=0.6
C0 iso_tail m1_3440_500# 0.0015f
C1 iso_tail m1_1000_500# 0.0015f
C2 sense_n iso_n 0.02157f
C3 iso_p iso_n 0.00782f
C4 m2_900_1400# iso_n 0.41846f
C5 sense_n m2_900_1400# 0.04273f
C6 m1_3440_500# iso_n 0.0015f
C7 iso_p m2_900_1400# 0.41846f
C8 sense_n m1_3440_500# 0.04555f
C9 sense_p iso_p 0.02157f
C10 m1_1000_500# iso_p 0.0015f
C11 iso_tail iso_n 0.05717f
C12 sense_p m2_900_1400# 0.04273f
C13 m2_900_1400# m1_3440_500# 0.01113f
C14 m1_1000_500# m2_900_1400# 0.01113f
C15 iso_tail sense_n 0.11179f
C16 sense_p m1_1000_500# 0.04555f
C17 iso_tail iso_p 0.05749f
C18 iso_tail m2_900_1400# 0.34398f
C19 iso_tail sense_p 0.12292f
C20 iso_n VSUBS 1.04634f
C21 iso_p VSUBS 1.04634f
C22 iso_tail VSUBS 4.24257f
C23 m2_900_1400# VSUBS 1.01648f
C24 m1_3440_500# VSUBS 0.31893f
C25 m1_1000_500# VSUBS 0.31893f
.ends

.subckt escaped_input_latch out_p out_n latch_sense_p latch_sense_n tail reset vdd
+ vss eval sense_p sense_n iso_tail vdd_active
X0 out_p out_n vdd_active vdd_active sky130_fd_pr__pfet_01v8 ad=3.36 pd=8 as=3.12 ps=7.6 w=1.2 l=0.6
X1 vdd reset out_n vdd sky130_fd_pr__pfet_01v8 ad=3.12 pd=7.6 as=3.36 ps=8 w=1.2 l=0.6
X2 tail out_p out_n vss sky130_fd_pr__nfet_01v8 ad=3.12 pd=7.6 as=3.36 ps=8 w=1.2 l=0.6
X3 out_p reset vdd vdd sky130_fd_pr__pfet_01v8 ad=3.36 pd=8 as=3.12 ps=7.6 w=1.2 l=0.6
X4 out_p out_n tail vss sky130_fd_pr__nfet_01v8 ad=3.36 pd=8 as=3.12 ps=7.6 w=1.2 l=0.6
X5 tail latch_sense_n out_n vss sky130_fd_pr__nfet_01v8 ad=3.12 pd=7.6 as=3.36 ps=8 w=1.2 l=0.6
X6 tail eval vss vss sky130_fd_pr__nfet_01v8 ad=16.2 pd=17.4 as=16.2 ps=17.4 w=6 l=0.6
X7 out_p latch_sense_p tail vss sky130_fd_pr__nfet_01v8 ad=3.36 pd=8 as=3.12 ps=7.6 w=1.2 l=0.6
X8 iso_tail sense_n latch_sense_n vss sky130_fd_pr__nfet_01v8 ad=3.12 pd=7.6 as=3.36 ps=8 w=1.2 l=0.6
X9 vdd_active out_p out_n vdd_active sky130_fd_pr__pfet_01v8 ad=3.12 pd=7.6 as=3.36 ps=8 w=1.2 l=0.6
X10 latch_sense_p sense_p iso_tail vss sky130_fd_pr__nfet_01v8 ad=3.36 pd=8 as=3.12 ps=7.6 w=1.2 l=0.6
C0 tail latch_sense_n 0.0334f
C1 latch_sense_n iso_tail 0.20888f
C2 tail out_n 0.46979f
C3 reset out_p 0.376f
C4 sense_p latch_sense_p 0.22977f
C5 latch_sense_p out_p 0.18428f
C6 vdd out_p 0.76206f
C7 vdd_active out_p 3.06556f
C8 out_n out_p 2.54301f
C9 reset vdd 4.47121f
C10 out_n reset 0.31048f
C11 sense_p iso_tail 0.26105f
C12 tail out_p 0.46979f
C13 latch_sense_n sense_n 0.22977f
C14 out_n vdd 0.77104f
C15 tail eval 0.35666f
C16 vdd_active out_n 3.16716f
C17 tail reset 0.16491f
C18 latch_sense_n out_n 0.18428f
C19 tail latch_sense_p 0.0334f
C20 latch_sense_p iso_tail 0.20888f
C21 tail vdd 0.9918f
C22 iso_tail sense_n 0.10725f
C23 tail vdd_active 0.9938f
C24 iso_tail vss 29.23796f
C25 latch_sense_n vss 1.7693f
C26 latch_sense_p vss 1.56796f
C27 out_n vss 13.58747f
C28 tail vss 89.03816f
C29 vdd_active vss 90.11912f
C30 vdd vss 78.65506f
.ends

.subckt aimc_converter_macro_active_candidate vss vdd row_drive sar_comparator_input
+ decision_p decision_n reset eval vss_escape vdd_ext iso_tail_ext tail_ext
Xphysical_preamp_0 physical_preamp_0/iso_tail physical_preamp_0/iso_p physical_preamp_0/iso_n
+ physical_preamp_0/sense_p physical_preamp_0/sense_n sar_comparator_input row_drive
+ physical_preamp_0/m2_900_1400# vss_escape sky130_transistor_active_isolation_pair
Xconverter_latch_0 decision_p decision_n vdd_ext vdd_ext tail_ext reset vdd_ext vss_escape
+ eval row_drive sar_comparator_input iso_tail_ext vdd_ext escaped_input_latch
C0 physical_preamp_0/m2_900_1400# physical_preamp_0/iso_n -0
C1 sar_comparator_input physical_preamp_0/iso_n 0.027f
C2 shared_converter_mux_0/vss vdd_ext 0
C3 shared_converter_mux_0/vdd vdd_ext 0
C4 reset tail_ext 0.01085f
C5 decision_p tail_ext 0.01085f
C6 vdd_ext physical_preamp_0/iso_n 0.0271f
C7 eval tail_ext 0.01085f
C8 reset vdd_ext 0.01669f
C9 decision_p vdd_ext 0
C10 eval vdd_ext 0
C11 physical_preamp_0/m2_900_1400# sar_comparator_input 0.16477f
C12 row_drive vdd 0.1964f
C13 physical_preamp_0/m2_900_1400# vdd_ext 0.16718f
C14 sar_comparator_input vdd_ext 0.80253f
C15 row_drive iso_tail_ext 1.71857f
C16 physical_preamp_0/m2_900_1400# physical_preamp_0/sense_n -0.00318f
C17 row_drive physical_preamp_0/iso_tail 0.02322f
C18 sar_comparator_input physical_preamp_0/sense_n 0.02993f
C19 sar_readout_12b_0/vss vdd_ext 0.93663f
C20 vdd_ext physical_preamp_0/sense_n 0.0103f
C21 shared_converter_mux_0/mux_bus row_drive 0.06281f
C22 row_drive row_dac_10b_0/vdd 1.11462f
C23 physical_preamp_0/m2_900_1400# physical_preamp_0/sense_p -0.00637f
C24 vss row_drive 0.22445f
C25 physical_preamp_0/sense_p sar_comparator_input 0.04049f
C26 row_drive sar_readout_12b_0/vdd 0.57218f
C27 physical_preamp_0/m2_900_1400# physical_preamp_0/iso_p 0
C28 physical_preamp_0/iso_p sar_comparator_input 0.02717f
C29 shared_converter_mux_0/vss row_drive 0.00246f
C30 iso_tail_ext sar_readout_12b_0/vdd 0.27521f
C31 physical_preamp_0/sense_p vdd_ext 0.03222f
C32 shared_converter_mux_0/vdd row_drive 0.00246f
C33 physical_preamp_0/iso_p vdd_ext 0.03623f
C34 vss shared_converter_mux_0/mux_bus 0.03132f
C35 shared_converter_mux_0/vss shared_converter_mux_0/mux_bus 1.56188f
C36 m1_69940_2940# m3_69940_2940# 0.03103f
C37 physical_preamp_0/m2_900_1400# row_drive -0.00731f
C38 sar_comparator_input row_drive 5.23145f
C39 shared_converter_mux_0/vdd shared_converter_mux_0/mux_bus 1.55306f
C40 sar_readout_12b_0/vss row_drive 0.29422f
C41 sar_comparator_input iso_tail_ext 0.05996f
C42 row_drive row_dac_10b_0/vss 1.08123f
C43 sar_comparator_input physical_preamp_0/iso_tail 0.0361f
C44 vss shared_converter_mux_0/vdd 0.2816f
C45 row_drive vdd_ext 2.79135f
C46 sar_readout_12b_0/vss iso_tail_ext 0.60045f
C47 vdd_ext iso_tail_ext 0.48802f
C48 vdd_ext physical_preamp_0/iso_tail 0.20594f
C49 decision_n tail_ext 0.01085f
C50 shared_converter_mux_0/mux_bus vdd_ext 0.00217f
C51 row_dac_10b_0/vdd row_dac_10b_0/vss 0.78467f
C52 physical_preamp_0/sense_p row_drive 0.0365f
C53 sar_readout_12b_0/vss sar_readout_12b_0/vdd 0.49712f
C54 vss vdd_ext 0.66116f
C55 vdd_ext sar_readout_12b_0/vdd 1.39936f
C56 physical_preamp_0/iso_p row_drive -0
C57 vss vss_escape 36.7f
C58 vdd vss_escape 36.7f
C59 m3_69940_2940# vss_escape 0.18641f ; **FLOATING
C60 m1_69940_2940# vss_escape 0.19727f ; **FLOATING
C61 iso_tail_ext vss_escape -1.05232f
C62 sar_comparator_input vss_escape 10.29198f
C63 decision_n vss_escape 3.8093f
C64 eval vss_escape 0.78348f
C65 row_drive vss_escape 19.1035f
C66 vdd_ext vss_escape 42.24193f
.ends
