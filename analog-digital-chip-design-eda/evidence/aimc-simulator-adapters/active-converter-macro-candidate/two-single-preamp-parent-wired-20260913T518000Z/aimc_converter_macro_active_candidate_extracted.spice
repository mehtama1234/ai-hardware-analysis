* NGSPICE file created from aimc_converter_macro_active_candidate_flat.ext - technology: sky130A

.subckt aimc_converter_macro_active_candidate_flat vss vdd row_drive decision_p decision_n
+ reset eval vss_escape latch_sense_p_ext latch_sense_n_ext iso_tail_ext tail_ext
+ vdd_ext
X0 latch_sense_n_ext row_drive preamp_iso_tail_ext vss_escape sky130_fd_pr__nfet_01v8 ad=3.36 pd=8 as=3.12 ps=7.6 w=1.2 l=0.6
X1 vdd_ext decision_p decision_n vdd_ext sky130_fd_pr__pfet_01v8 ad=3.12 pd=7.6 as=3.36 ps=8 w=1.2 l=0.6
X2 tail_ext eval vss_escape vss_escape sky130_fd_pr__nfet_01v8 ad=16.2 pd=17.4 as=16.2 ps=17.4 w=6 l=0.6
X3 decision_p latch_sense_p_ext tail_ext vss_escape sky130_fd_pr__nfet_01v8 ad=3.36 pd=8 as=3.12 ps=7.6 w=1.2 l=0.6
X4 vdd_ext reset decision_n vdd_ext sky130_fd_pr__pfet_01v8 ad=3.12 pd=7.6 as=3.36 ps=8 w=1.2 l=0.6
X5 tail_ext latch_sense_n_ext decision_n vss_escape sky130_fd_pr__nfet_01v8 ad=3.12 pd=7.6 as=3.36 ps=8 w=1.2 l=0.6
X6 decision_p decision_n vdd_ext vdd_ext sky130_fd_pr__pfet_01v8 ad=3.36 pd=8 as=3.12 ps=7.6 w=1.2 l=0.6
X7 tail_ext decision_p decision_n vss_escape sky130_fd_pr__nfet_01v8 ad=3.12 pd=7.6 as=3.36 ps=8 w=1.2 l=0.6
X8 latch_sense_p_ext row_drive iso_tail_ext vss_escape sky130_fd_pr__nfet_01v8 ad=3.36 pd=8 as=3.12 ps=7.6 w=1.2 l=0.6
X9 iso_tail_ext row_drive latch_sense_n_ext vss_escape sky130_fd_pr__nfet_01v8 ad=3.12 pd=7.6 as=3.36 ps=8 w=1.2 l=0.6
X10 latch_sense_p_ext row_drive preamp_iso_tail_ext vss_escape sky130_fd_pr__nfet_01v8 ad=3.36 pd=8 as=3.12 ps=7.6 w=1.2 l=0.6
X11 decision_p reset vdd_ext vdd_ext sky130_fd_pr__pfet_01v8 ad=3.36 pd=8 as=3.12 ps=7.6 w=1.2 l=0.6
X12 decision_p decision_n tail_ext vss_escape sky130_fd_pr__nfet_01v8 ad=3.36 pd=8 as=3.12 ps=7.6 w=1.2 l=0.6
C0 eval latch_sense_p_ext 0.19752f
C1 tail_ext decision_p 0.48065f
C2 sar_readout_12b_0.vss vdd_ext 0.93663f
C3 iso_tail_ext vdd_ext 0.86179f
C4 row_dac_10b_0.vdd row_drive 1.11462f
C5 row_drive vdd_ext 6.45516f
C6 row_dac_10b_0.vss row_drive 1.08123f
C7 shared_converter_mux_0.mux_bus shared_converter_mux_0.vss 1.56188f
C8 reset vdd_ext 4.48789f
C9 preamp_iso_tail_ext row_drive 0.17138f
C10 m4_45060_36440# latch_sense_p_ext 0.00708f
C11 latch_sense_n_ext vdd_ext 4.55721f
C12 iso_tail_ext latch_sense_p_ext 0.1295f
C13 preamp_iso_tail_ext latch_sense_n_ext 0.36983f
C14 latch_sense_p_ext row_drive 1.40276f
C15 shared_converter_mux_0.mux_bus vss 0.03132f
C16 reset latch_sense_p_ext 0.19529f
C17 shared_converter_mux_0.vdd vss 0.2816f
C18 decision_n tail_ext 0.48065f
C19 reset decision_p 0.376f
C20 shared_converter_mux_0.vss row_drive 0.00246f
C21 sar_readout_12b_0.vss sar_readout_12b_0.vdd 0.49712f
C22 row_dac_10b_0.vss row_dac_10b_0.vdd 0.78467f
C23 m1_68300_3080# row_drive 2.81114f
C24 preamp_iso_tail_ext vdd_ext 0.01021f
C25 iso_tail_ext sar_readout_12b_0.vdd 0.27521f
C26 latch_sense_n_ext latch_sense_p_ext 0.59927f
C27 eval tail_ext 0.36751f
C28 m4_32000_38940# latch_sense_n_ext 0.0096f
C29 sar_readout_12b_0.vdd row_drive 0.58157f
C30 m4_51060_36440# row_drive 0.0704f
C31 latch_sense_p_ext vdd_ext 5.38438f
C32 vss row_drive 0.4489f
C33 preamp_iso_tail_ext latch_sense_p_ext 0.28327f
C34 shared_converter_mux_0.vdd shared_converter_mux_0.mux_bus 1.55306f
C35 decision_p vdd_ext 3.8282f
C36 shared_converter_mux_0.vss vdd_ext 0
C37 m1_68300_3080# vdd_ext 0.24419f
C38 m4_51060_36440# latch_sense_n_ext 0.00671f
C39 vss latch_sense_n_ext 0.29037f
C40 decision_n row_drive 0.07411f
C41 sar_readout_12b_0.vdd vdd_ext 1.39936f
C42 reset decision_n 0.31048f
C43 reset tail_ext 0.17577f
C44 m4_32000_38940# latch_sense_p_ext 0.00354f
C45 decision_p latch_sense_p_ext 0.37635f
C46 m4_51060_36440# vdd_ext 0.01404f
C47 vss vdd_ext 0.19458f
C48 decision_n latch_sense_n_ext 0.37635f
C49 shared_converter_mux_0.mux_bus row_drive 0.06281f
C50 preamp_iso_tail_ext m4_51060_36440# 0.00179f
C51 m2_42000_41940# row_drive 0.12051f
C52 tail_ext latch_sense_n_ext 1.09601f
C53 shared_converter_mux_0.vdd row_drive 0.00246f
C54 m4_45060_36440# row_drive 0.10664f
C55 sar_readout_12b_0.vss iso_tail_ext 0.60045f
C56 decision_n vdd_ext 3.9382f
C57 tail_ext vdd_ext 1.9856f
C58 sar_readout_12b_0.vss row_drive 0.29433f
C59 vss latch_sense_p_ext 0.29037f
C60 iso_tail_ext row_drive 2.56426f
C61 eval vdd_ext 0
C62 m4_45060_36440# latch_sense_n_ext 0.00655f
C63 shared_converter_mux_0.mux_bus vdd_ext 0.00217f
C64 shared_converter_mux_0.vdd vdd_ext 0
C65 iso_tail_ext latch_sense_n_ext 0.12999f
C66 tail_ext latch_sense_p_ext 0.99589f
C67 vdd row_drive 0.1964f
C68 m4_45060_36440# vdd_ext 0.01404f
C69 latch_sense_n_ext row_drive 1.0259f
C70 preamp_iso_tail_ext m4_45060_36440# 0
C71 decision_n decision_p 2.54301f
C72 vss vss_escape 36.2394f
C73 vdd vss_escape 36.7f
C74 iso_tail_ext vss_escape 20.9682f
C75 decision_p vss_escape 16.64813f
C76 tail_ext vss_escape 0.17021p
C77 vdd_ext vss_escape 0.27757p
C78 m4_51060_36440# vss_escape 0.12744f ; **FLOATING
C79 m4_45060_36440# vss_escape 0.09034f ; **FLOATING
C80 m4_32000_38940# vss_escape 0.1568f ; **FLOATING
C81 m2_42000_41940# vss_escape 3.91591f ; **FLOATING
C82 sar_readout_12b_0.vss vss_escape 1.33686f ; **FLOATING
C83 row_dac_10b_0.vss vss_escape 1.40333f ; **FLOATING
C84 row_dac_10b_0.vdd vss_escape 1.33457f ; **FLOATING
C85 sar_readout_12b_0.vdd vss_escape 1.77614f ; **FLOATING
C86 m1_68300_3080# vss_escape 7.86858f ; **FLOATING
C87 shared_converter_mux_0.vss vss_escape 1.39454f ; **FLOATING
C88 shared_converter_mux_0.mux_bus vss_escape 2.86922f ; **FLOATING
C89 shared_converter_mux_0.vdd vss_escape 0.95985f ; **FLOATING
C90 preamp_iso_tail_ext vss_escape 78.7565f
.ends
