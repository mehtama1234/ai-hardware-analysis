* NGSPICE file created from aimc_converter_macro_active_candidate.ext - technology: sky130A

.subckt escaped_input_latch out_p out_n latch_sense_p latch_sense_n tail reset vdd
+ vss eval sense_p sense_n iso_tail vdd_active
X0 out_p out_n vdd_active vdd_active sky130_fd_pr__pfet_01v8 ad=6.72 pd=10.4 as=6.24 ps=10 w=2.4 l=0.6
X1 vdd reset out_n vdd sky130_fd_pr__pfet_01v8 ad=3.12 pd=7.6 as=3.36 ps=8 w=1.2 l=0.6
X2 tail out_p out_n vss sky130_fd_pr__nfet_01v8 ad=12.48 pd=14.8 as=13.44 ps=15.2 w=4.8 l=0.6
X3 out_p reset vdd vdd sky130_fd_pr__pfet_01v8 ad=3.36 pd=8 as=3.12 ps=7.6 w=1.2 l=0.6
X4 out_p out_n tail vss sky130_fd_pr__nfet_01v8 ad=13.44 pd=15.2 as=12.48 ps=14.8 w=4.8 l=0.6
X5 tail latch_sense_n out_n vss sky130_fd_pr__nfet_01v8 ad=12.48 pd=14.8 as=13.44 ps=15.2 w=4.8 l=0.6
X6 tail eval vss vss sky130_fd_pr__nfet_01v8 ad=16.2 pd=17.4 as=16.2 ps=17.4 w=6 l=0.6
X7 out_p latch_sense_p tail vss sky130_fd_pr__nfet_01v8 ad=13.44 pd=15.2 as=12.48 ps=14.8 w=4.8 l=0.6
X8 iso_tail sense_n latch_sense_n vss sky130_fd_pr__nfet_01v8 ad=3.12 pd=7.6 as=3.36 ps=8 w=1.2 l=0.6
X9 vdd_active out_p out_n vdd_active sky130_fd_pr__pfet_01v8 ad=6.24 pd=10 as=6.72 ps=10.4 w=2.4 l=0.6
X10 latch_sense_p sense_p iso_tail vss sky130_fd_pr__nfet_01v8 ad=3.36 pd=8 as=3.12 ps=7.6 w=1.2 l=0.6
C0 out_p vdd_active 2.82313f
C1 tail out_n 0.18071f
C2 iso_tail sense_n 0.10725f
C3 tail vdd 0.94872f
C4 iso_tail sense_p 0.10725f
C5 latch_sense_n out_n 0.15901f
C6 iso_tail latch_sense_n 0.07366f
C7 tail vdd_active 0.94872f
C8 tail out_p 0.18071f
C9 out_n reset 0.31048f
C10 reset vdd 4.03064f
C11 iso_tail latch_sense_p 0.07366f
C12 latch_sense_n sense_n 0.02861f
C13 tail latch_sense_n 0.0334f
C14 out_p reset 0.31048f
C15 out_n vdd 0.76206f
C16 latch_sense_p out_p 0.15901f
C17 out_n vdd_active 2.87636f
C18 out_n out_p 2.60132f
C19 eval tail 0.09547f
C20 out_p vdd 0.76206f
C21 sense_p latch_sense_p 0.02861f
C22 latch_sense_p tail 0.0334f
C23 iso_tail vss 25.79857f
C24 latch_sense_n vss 1.99533f
C25 latch_sense_p vss 1.99533f
C26 out_n vss 9.45902f
C27 tail vss 72.30894f
C28 vdd_active vss 81.54407f
C29 vdd vss 72.40037f
.ends

.subckt aimc_converter_macro_active_candidate vss vdd row_drive sar_comparator_input
Xconverter_latch_0 converter_latch_0/out_p converter_latch_0/out_n converter_latch_0/latch_sense_p
+ converter_latch_0/latch_sense_n converter_latch_0/tail converter_latch_0/reset converter_latch_0/vdd
+ VSUBS converter_latch_0/eval row_drive sar_comparator_input converter_latch_0/iso_tail
+ converter_latch_0/vdd_active escaped_input_latch
C0 converter_latch_0/iso_tail sar_readout_12b_0/vdd 0.27625f
C1 converter_latch_0/vdd_active row_drive 0.16074f
C2 shared_converter_mux_0/mux_bus shared_converter_mux_0/vss 1.56188f
C3 sar_readout_12b_0/sample_in sar_readout_12b_0/vdd 1.31601f
C4 sar_readout_12b_0/vdd row_drive 0.33566f
C5 converter_latch_0/iso_tail sar_comparator_input 0.08712f
C6 shared_converter_mux_0/vss row_drive 0.00246f
C7 converter_latch_0/iso_tail sar_readout_12b_0/vss 0.60149f
C8 vss shared_converter_mux_0/mux_bus 0.03132f
C9 row_dac_10b_0/vss row_dac_10b_0/vdd 0.78467f
C10 shared_converter_mux_0/mux_bus shared_converter_mux_0/vdd 1.55306f
C11 sar_readout_12b_0/sample_in sar_readout_12b_0/vss 0.93592f
C12 vss shared_converter_mux_0/vdd 0.2816f
C13 vss converter_latch_0/latch_sense_p 0.23329f
C14 row_dac_10b_0/vss row_drive 1.08123f
C15 sar_readout_12b_0/vss row_drive 0.21493f
C16 sar_readout_12b_0/sample_in converter_latch_0/iso_tail 0.31109f
C17 shared_converter_mux_0/mux_bus row_drive 0.06281f
C18 vdd row_drive 0.1964f
C19 vss row_drive 0.22445f
C20 sar_readout_12b_0/vdd sar_readout_12b_0/vss 0.49712f
C21 converter_latch_0/iso_tail row_drive 0.26293f
C22 converter_latch_0/vdd row_drive 0.46275f
C23 shared_converter_mux_0/vdd row_drive 0.00246f
C24 row_dac_10b_0/vdd row_drive 1.11409f
C25 sar_readout_12b_0/sample_in row_drive 0.72201f
C26 vss converter_latch_0/latch_sense_n 0.23329f
C27 vss VSUBS 22.6565f
C28 vdd VSUBS 22.6565f
C29 sar_comparator_input VSUBS 0.93057f
C30 row_drive VSUBS 6.8891f
.ends
