.subckt preamp_p_nfet source drain gate body
X0 drain gate source body sky130_fd_pr__nfet_01v8 w=1.2 l=0.6
.ends preamp_p_nfet
