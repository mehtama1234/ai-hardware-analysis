* NGSPICE file created from aimc_converter_macro_active_candidate.ext - technology: sky130A

.subckt sky130_transistor_active_isolation_pair iso_tail iso_p iso_n sense_p sense_n
+ m1_3440_500# m1_1000_500# m2_900_1400# VSUBS
X0 iso_tail sense_n iso_n VSUBS sky130_fd_pr__nfet_01v8 ad=3.12 pd=7.6 as=3.36 ps=8 w=1.2 l=0.6
X1 iso_p sense_p iso_tail VSUBS sky130_fd_pr__nfet_01v8 ad=3.36 pd=8 as=3.12 ps=7.6 w=1.2 l=0.6
C0 m2_900_1400# sense_n 0.04273f
C1 iso_tail iso_n 0.05717f
C2 m2_900_1400# m1_3440_500# 0.01113f
C3 m1_1000_500# iso_tail 0.0015f
C4 m2_900_1400# sense_p 0.04273f
C5 m2_900_1400# iso_n 0.41846f
C6 m2_900_1400# m1_1000_500# 0.01113f
C7 m2_900_1400# iso_tail 0.34398f
C8 iso_p sense_p 0.02157f
C9 m1_3440_500# sense_n 0.04555f
C10 iso_p iso_n 0.00782f
C11 m1_1000_500# iso_p 0.0015f
C12 iso_tail iso_p 0.05749f
C13 sense_n iso_n 0.02157f
C14 iso_tail sense_n 0.11179f
C15 m1_3440_500# iso_n 0.0015f
C16 iso_tail m1_3440_500# 0.0015f
C17 m1_1000_500# sense_p 0.04555f
C18 iso_tail sense_p 0.12292f
C19 m2_900_1400# iso_p 0.41846f
C20 iso_n VSUBS 1.04634f
C21 iso_p VSUBS 1.04634f
C22 iso_tail VSUBS 4.24257f
C23 m2_900_1400# VSUBS 1.01648f
C24 m1_3440_500# VSUBS 0.31893f
C25 m1_1000_500# VSUBS 0.31893f
.ends

.subckt escaped_input_latch out_p out_n latch_sense_p latch_sense_n tail reset vdd
+ vss eval sense_p sense_n iso_tail vdd_active
X0 out_p out_n vdd_active vdd_active sky130_fd_pr__pfet_01v8 ad=3.36 pd=8 as=3.12 ps=7.6 w=1.2 l=0.6
X1 vdd reset out_n vdd sky130_fd_pr__pfet_01v8 ad=3.12 pd=7.6 as=3.36 ps=8 w=1.2 l=0.6
X2 tail out_p out_n vss sky130_fd_pr__nfet_01v8 ad=3.12 pd=7.6 as=3.36 ps=8 w=1.2 l=0.6
X3 out_p reset vdd vdd sky130_fd_pr__pfet_01v8 ad=3.36 pd=8 as=3.12 ps=7.6 w=1.2 l=0.6
X4 out_p out_n tail vss sky130_fd_pr__nfet_01v8 ad=3.36 pd=8 as=3.12 ps=7.6 w=1.2 l=0.6
X5 tail latch_sense_n out_n vss sky130_fd_pr__nfet_01v8 ad=3.12 pd=7.6 as=3.36 ps=8 w=1.2 l=0.6
X6 tail eval vss vss sky130_fd_pr__nfet_01v8 ad=16.2 pd=17.4 as=16.2 ps=17.4 w=6 l=0.6
X7 out_p latch_sense_p tail vss sky130_fd_pr__nfet_01v8 ad=3.36 pd=8 as=3.12 ps=7.6 w=1.2 l=0.6
X8 iso_tail sense_n latch_sense_n vss sky130_fd_pr__nfet_01v8 ad=3.12 pd=7.6 as=3.36 ps=8 w=1.2 l=0.6
X9 vdd_active out_p out_n vdd_active sky130_fd_pr__pfet_01v8 ad=3.12 pd=7.6 as=3.36 ps=8 w=1.2 l=0.6
X10 latch_sense_p sense_p iso_tail vss sky130_fd_pr__nfet_01v8 ad=3.36 pd=8 as=3.12 ps=7.6 w=1.2 l=0.6
C0 latch_sense_p out_p 0.18428f
C1 tail latch_sense_p 0.0334f
C2 out_n out_p 2.54301f
C3 tail out_p 0.46979f
C4 iso_tail latch_sense_p 0.20888f
C5 out_n tail 0.46979f
C6 latch_sense_p sense_p 0.22977f
C7 vdd out_p 0.76206f
C8 iso_tail sense_n 0.10725f
C9 vdd out_n 0.77104f
C10 vdd tail 0.9918f
C11 out_n latch_sense_n 0.18428f
C12 tail latch_sense_n 0.0334f
C13 iso_tail sense_p 0.26105f
C14 iso_tail latch_sense_n 0.20888f
C15 latch_sense_n sense_n 0.22977f
C16 reset out_p 0.376f
C17 out_n reset 0.31048f
C18 tail reset 0.16491f
C19 tail eval 0.35666f
C20 vdd_active out_p 3.06556f
C21 out_n vdd_active 3.16716f
C22 tail vdd_active 0.9938f
C23 vdd reset 4.47121f
C24 iso_tail vss 29.23796f
C25 latch_sense_n vss 1.7693f
C26 latch_sense_p vss 1.56796f
C27 out_n vss 13.58747f
C28 tail vss 89.03816f
C29 vdd_active vss 90.11912f
C30 vdd vss 78.65506f
.ends

.subckt aimc_converter_macro_active_candidate vss vdd row_drive sar_comparator_input
+ decision_p decision_n reset eval vss_escape latch_sense_p_ext iso_tail_ext tail_ext
+ vdd_ext preamp_iso_tail_ext
Xphysical_preamp_0 physical_preamp_0/iso_tail physical_preamp_0/iso_p physical_preamp_0/iso_n
+ physical_preamp_0/sense_p physical_preamp_0/sense_n sar_comparator_input row_drive
+ physical_preamp_0/m2_900_1400# vss_escape sky130_transistor_active_isolation_pair
Xconverter_latch_0 decision_p decision_n latch_sense_p_ext latch_sense_p_ext tail_ext
+ reset vdd_ext vss_escape eval row_drive sar_comparator_input iso_tail_ext vdd_ext
+ escaped_input_latch
C0 sar_comparator_input physical_preamp_0/iso_n 0.027f
C1 physical_preamp_0/iso_tail row_drive 0.02329f
C2 sar_comparator_input iso_tail_ext 0.05996f
C3 eval tail_ext 0.01085f
C4 decision_n tail_ext 0.01085f
C5 shared_converter_mux_0/vdd shared_converter_mux_0/mux_bus 1.55306f
C6 m1_67140_3540# vss 0.00501f
C7 sar_readout_12b_0/vss iso_tail_ext 0.60045f
C8 vdd_ext shared_converter_mux_0/mux_bus 0.00217f
C9 row_drive sar_readout_12b_0/vdd 0.57218f
C10 latch_sense_p_ext row_drive 1.05617f
C11 latch_sense_p_ext physical_preamp_0/m2_900_1400# 0.04877f
C12 vss latch_sense_p_ext 0.46658f
C13 shared_converter_mux_0/vdd vdd_ext 0
C14 row_dac_10b_0/vdd row_drive 1.11462f
C15 row_drive shared_converter_mux_0/vss 0.00246f
C16 physical_preamp_0/iso_p sar_comparator_input 0.02717f
C17 physical_preamp_0/sense_p sar_comparator_input 0.04049f
C18 m1_65540_3540# m1_67140_3540# 0.01594f
C19 physical_preamp_0/iso_tail m1_65540_3540# 0.00501f
C20 tail_ext decision_p 0.01085f
C21 eval vdd_ext 0
C22 row_drive iso_tail_ext 1.71857f
C23 physical_preamp_0/iso_n physical_preamp_0/m2_900_1400# -0
C24 tail_ext reset 0.01085f
C25 m1_65540_3540# latch_sense_p_ext 0.00702f
C26 shared_converter_mux_0/mux_bus shared_converter_mux_0/vss 1.56188f
C27 vdd_ext sar_readout_12b_0/vdd 1.39936f
C28 vdd_ext latch_sense_p_ext 0.24878f
C29 physical_preamp_0/iso_tail m1_67140_3540# 0.00501f
C30 latch_sense_p_ext physical_preamp_0/sense_n 0.00257f
C31 row_dac_10b_0/vss row_drive 1.08123f
C32 vdd_ext decision_p 0
C33 physical_preamp_0/iso_p row_drive -0
C34 preamp_iso_tail_ext m1_69940_2940# 0.03103f
C35 physical_preamp_0/sense_p row_drive 0.03836f
C36 physical_preamp_0/iso_p physical_preamp_0/m2_900_1400# 0
C37 vdd_ext shared_converter_mux_0/vss 0
C38 physical_preamp_0/sense_p physical_preamp_0/m2_900_1400# -0.00637f
C39 sar_comparator_input row_drive 5.23145f
C40 physical_preamp_0/iso_tail latch_sense_p_ext 0.11036f
C41 sar_comparator_input physical_preamp_0/m2_900_1400# 0.16477f
C42 vdd_ext reset 0.01669f
C43 sar_readout_12b_0/vss row_drive 0.29422f
C44 vdd_ext iso_tail_ext 0.3078f
C45 iso_tail_ext sar_readout_12b_0/vdd 0.27521f
C46 physical_preamp_0/iso_n latch_sense_p_ext 0.00416f
C47 latch_sense_p_ext iso_tail_ext 0.44179f
C48 row_drive physical_preamp_0/m2_900_1400# -0.00731f
C49 sar_comparator_input vdd_ext 0.06859f
C50 vss row_drive 0.22445f
C51 vdd_ext sar_readout_12b_0/vss 0.93663f
C52 sar_comparator_input physical_preamp_0/sense_n 0.02993f
C53 vdd row_drive 0.1964f
C54 physical_preamp_0/iso_tail sar_comparator_input 0.0361f
C55 physical_preamp_0/iso_p latch_sense_p_ext 0.01559f
C56 row_drive shared_converter_mux_0/mux_bus 0.06281f
C57 physical_preamp_0/sense_p latch_sense_p_ext 0.02192f
C58 vss shared_converter_mux_0/mux_bus 0.03132f
C59 sar_comparator_input latch_sense_p_ext 0.4814f
C60 row_dac_10b_0/vdd row_dac_10b_0/vss 0.78467f
C61 shared_converter_mux_0/vdd row_drive 0.00246f
C62 m1_65540_3540# vss 0.00501f
C63 sar_readout_12b_0/vss sar_readout_12b_0/vdd 0.49712f
C64 shared_converter_mux_0/vdd vss 0.2816f
C65 vdd_ext row_drive 2.1538f
C66 vdd_ext vss 0.19458f
C67 physical_preamp_0/sense_n physical_preamp_0/m2_900_1400# -0.00318f
C68 preamp_iso_tail_ext vss_escape 0.18641f
C69 vss vss_escape 36.6898f
C70 vdd vss_escape 36.7f
C71 m1_69940_2940# vss_escape 0.19727f ; **FLOATING
C72 m1_67140_3540# vss_escape 0.41976f ; **FLOATING
C73 m1_65540_3540# vss_escape 0.40731f ; **FLOATING
C74 iso_tail_ext vss_escape -1.05232f
C75 sar_comparator_input vss_escape 10.66696f
C76 latch_sense_p_ext vss_escape 9.6893f
C77 decision_n vss_escape 3.8093f
C78 eval vss_escape 0.78348f
C79 row_drive vss_escape 19.1176f
C80 vdd_ext vss_escape 34.08534f
.ends
