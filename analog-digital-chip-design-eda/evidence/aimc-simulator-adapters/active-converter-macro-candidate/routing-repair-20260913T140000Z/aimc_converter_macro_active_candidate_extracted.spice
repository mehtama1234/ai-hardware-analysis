* NGSPICE file created from aimc_converter_macro_active_candidate_flat.ext - technology: sky130A

* Top level circuit aimc_converter_macro_active_candidate_flat

C0 m1_0_0# VSUBS 0 ; **FLOATING
.end
