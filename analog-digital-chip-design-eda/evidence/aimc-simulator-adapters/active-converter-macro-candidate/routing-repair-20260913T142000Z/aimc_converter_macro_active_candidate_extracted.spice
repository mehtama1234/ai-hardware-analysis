* NGSPICE file created from aimc_converter_macro_active_candidate_flat.ext - technology: sky130A

.subckt aimc_converter_macro_active_candidate_flat vss vdd row_drive decision_p decision_n
+ reset eval vss_escape latch_sense_p_ext latch_sense_n_ext iso_tail_ext tail_ext
+ vdd_ext
X0 physical_preamp_0.iso_tail physical_preamp_0.sense_n physical_preamp_0.iso_n vss_escape sky130_fd_pr__nfet_01v8 ad=3.12 pd=7.6 as=3.36 ps=8 w=1.2 l=0.6
X1 vdd_ext decision_p decision_n vdd_ext sky130_fd_pr__pfet_01v8 ad=3.12 pd=7.6 as=3.36 ps=8 w=1.2 l=0.6
X2 tail_ext eval vss_escape vss_escape sky130_fd_pr__nfet_01v8 ad=16.2 pd=17.4 as=16.2 ps=17.4 w=6 l=0.6
X3 physical_preamp_0.iso_p physical_preamp_0.sense_p physical_preamp_0.iso_tail vss_escape sky130_fd_pr__nfet_01v8 ad=3.36 pd=8 as=3.12 ps=7.6 w=1.2 l=0.6
X4 decision_p latch_sense_p_ext tail_ext vss_escape sky130_fd_pr__nfet_01v8 ad=3.36 pd=8 as=3.12 ps=7.6 w=1.2 l=0.6
X5 vdd_ext reset decision_n vdd_ext sky130_fd_pr__pfet_01v8 ad=3.12 pd=7.6 as=3.36 ps=8 w=1.2 l=0.6
X6 tail_ext latch_sense_n_ext decision_n vss_escape sky130_fd_pr__nfet_01v8 ad=3.12 pd=7.6 as=3.36 ps=8 w=1.2 l=0.6
X7 decision_p decision_n vdd_ext vdd_ext sky130_fd_pr__pfet_01v8 ad=3.36 pd=8 as=3.12 ps=7.6 w=1.2 l=0.6
X8 tail_ext decision_p decision_n vss_escape sky130_fd_pr__nfet_01v8 ad=3.12 pd=7.6 as=3.36 ps=8 w=1.2 l=0.6
X9 latch_sense_p_ext row_drive iso_tail_ext vss_escape sky130_fd_pr__nfet_01v8 ad=3.36 pd=8 as=3.12 ps=7.6 w=1.2 l=0.6
X10 iso_tail_ext row_drive latch_sense_n_ext vss_escape sky130_fd_pr__nfet_01v8 ad=3.12 pd=7.6 as=3.36 ps=8 w=1.2 l=0.6
X11 decision_p reset vdd_ext vdd_ext sky130_fd_pr__pfet_01v8 ad=3.36 pd=8 as=3.12 ps=7.6 w=1.2 l=0.6
X12 decision_p decision_n tail_ext vss_escape sky130_fd_pr__nfet_01v8 ad=3.36 pd=8 as=3.12 ps=7.6 w=1.2 l=0.6
C0 physical_preamp_0.iso_tail row_drive 0.11982f
C1 sar_readout_12b_0.vss row_drive 0.29422f
C2 latch_sense_p_ext decision_p 0.18428f
C3 shared_converter_mux_0.vdd vdd_ext 0
C4 shared_converter_mux_0.vss vdd_ext 0
C5 vdd_ext latch_sense_p_ext 3.43095f
C6 vdd_ext m2_64900_1400# 0.07254f
C7 vdd_ext vss 0.21361f
C8 physical_preamp_0.iso_tail m3_42000_3080# 0.1213f
C9 vdd_ext physical_preamp_0.iso_p 0.02484f
C10 row_dac_10b_0.vss row_drive 1.08123f
C11 vdd_ext physical_preamp_0.iso_n 0.0106f
C12 tail_ext eval 0.36751f
C13 physical_preamp_0.sense_p row_drive 0.18727f
C14 physical_preamp_0.sense_p physical_preamp_0.iso_tail 0.12279f
C15 shared_converter_mux_0.vdd vss 0.2816f
C16 physical_preamp_0.sense_n vdd_ext 0.0039f
C17 vdd row_drive 0.1964f
C18 vss latch_sense_p_ext 0.23329f
C19 shared_converter_mux_0.mux_bus row_drive 0.06281f
C20 iso_tail_ext latch_sense_n_ext 0.12577f
C21 physical_preamp_0.sense_p m3_42000_3080# 0.00502f
C22 m2_64900_1400# physical_preamp_0.iso_p 0.41846f
C23 m2_64900_1400# physical_preamp_0.iso_n 0.41846f
C24 row_drive latch_sense_n_ext 0.24379f
C25 tail_ext decision_n 0.48065f
C26 physical_preamp_0.iso_p physical_preamp_0.iso_n 0.00782f
C27 physical_preamp_0.sense_n m2_64900_1400# 0.03901f
C28 sar_readout_12b_0.vdd iso_tail_ext 0.27521f
C29 tail_ext reset 0.17577f
C30 tail_ext latch_sense_n_ext 0.0334f
C31 physical_preamp_0.sense_n physical_preamp_0.iso_n 0.02157f
C32 sar_readout_12b_0.vdd row_drive 0.57218f
C33 vdd_ext iso_tail_ext 0.86179f
C34 row_dac_10b_0.vdd row_drive 1.11462f
C35 vdd_ext row_drive 3.76938f
C36 sar_readout_12b_0.vdd sar_readout_12b_0.vss 0.49712f
C37 vdd_ext physical_preamp_0.iso_tail 0.3323f
C38 vdd_ext sar_readout_12b_0.vss 0.93663f
C39 tail_ext decision_p 0.48065f
C40 iso_tail_ext latch_sense_p_ext 0.12577f
C41 reset decision_n 0.31048f
C42 eval vdd_ext 0
C43 latch_sense_n_ext decision_n 0.18428f
C44 tail_ext vdd_ext 1.9856f
C45 shared_converter_mux_0.vdd row_drive 0.00246f
C46 shared_converter_mux_0.vss row_drive 0.00246f
C47 row_drive latch_sense_p_ext 0.24412f
C48 vdd_ext m3_42000_3080# 0.66292f
C49 m2_64900_1400# row_drive 0.18484f
C50 row_dac_10b_0.vdd row_dac_10b_0.vss 0.78467f
C51 row_drive vss 0.22445f
C52 physical_preamp_0.iso_p row_drive 0.04554f
C53 m2_64900_1400# physical_preamp_0.iso_tail 0.3472f
C54 physical_preamp_0.iso_n row_drive 0.04554f
C55 physical_preamp_0.sense_p vdd_ext 0.03258f
C56 decision_n decision_p 2.54301f
C57 tail_ext latch_sense_p_ext 0.0334f
C58 physical_preamp_0.iso_tail physical_preamp_0.iso_p 0.05749f
C59 physical_preamp_0.iso_tail physical_preamp_0.iso_n 0.05717f
C60 vdd_ext decision_n 3.9382f
C61 m2_64900_1400# m3_42000_3080# 0.00202f
C62 physical_preamp_0.sense_n row_drive 0.10005f
C63 vdd_ext shared_converter_mux_0.mux_bus 0.00217f
C64 reset decision_p 0.376f
C65 physical_preamp_0.iso_p m3_42000_3080# 0.00159f
C66 physical_preamp_0.iso_n m3_42000_3080# 0.00159f
C67 physical_preamp_0.sense_n physical_preamp_0.iso_tail 0.1355f
C68 physical_preamp_0.sense_p m2_64900_1400# 0.03637f
C69 reset vdd_ext 4.48789f
C70 vdd_ext latch_sense_n_ext 3.48444f
C71 physical_preamp_0.sense_p physical_preamp_0.iso_p 0.02157f
C72 physical_preamp_0.sense_n m3_42000_3080# 0.00502f
C73 shared_converter_mux_0.vdd shared_converter_mux_0.mux_bus 1.55306f
C74 shared_converter_mux_0.vss shared_converter_mux_0.mux_bus 1.56188f
C75 shared_converter_mux_0.mux_bus vss 0.03132f
C76 sar_readout_12b_0.vdd vdd_ext 1.39936f
C77 vdd_ext decision_p 3.8282f
C78 row_drive iso_tail_ext 2.14683f
C79 vss latch_sense_n_ext 0.23329f
C80 sar_readout_12b_0.vss iso_tail_ext 0.60045f
C81 vss vss_escape 36.2211f
C82 vdd vss_escape 36.7f
C83 iso_tail_ext vss_escape 55.97575f
C84 latch_sense_p_ext vss_escape 33.92745f
C85 decision_p vss_escape 7.45999f
C86 tail_ext vss_escape 81.67176f
C87 vdd_ext vss_escape 0.25933p
C88 m3_42000_3080# vss_escape 11.7112f ; **FLOATING
C89 m2_64900_1400# vss_escape 0.71773f ; **FLOATING
C90 sar_readout_12b_0.vss vss_escape 1.33686f ; **FLOATING
C91 row_dac_10b_0.vss vss_escape 1.40333f ; **FLOATING
C92 row_dac_10b_0.vdd vss_escape 1.33457f ; **FLOATING
C93 sar_readout_12b_0.vdd vss_escape 1.77614f ; **FLOATING
C94 shared_converter_mux_0.vss vss_escape 1.39454f ; **FLOATING
C95 shared_converter_mux_0.mux_bus vss_escape 2.86922f ; **FLOATING
C96 shared_converter_mux_0.vdd vss_escape 0.95985f ; **FLOATING
C97 physical_preamp_0.iso_n vss_escape 1.01323f
C98 physical_preamp_0.iso_p vss_escape 1.01323f
C99 physical_preamp_0.iso_tail vss_escape 5.60088f
.ends
