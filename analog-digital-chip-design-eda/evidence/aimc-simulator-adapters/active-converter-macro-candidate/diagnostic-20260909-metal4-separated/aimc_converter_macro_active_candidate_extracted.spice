* NGSPICE file created from aimc_converter_macro_active_candidate.ext - technology: sky130A

.subckt sky130_transistor_active_isolation_pair iso_tail iso_p iso_n sense_p sense_n
+ m1_3440_500# m1_1000_500# m2_900_1400# VSUBS
X0 iso_tail sense_n iso_n VSUBS sky130_fd_pr__nfet_01v8 ad=3.12 pd=7.6 as=3.36 ps=8 w=1.2 l=0.6
X1 iso_p sense_p iso_tail VSUBS sky130_fd_pr__nfet_01v8 ad=3.36 pd=8 as=3.12 ps=7.6 w=1.2 l=0.6
C0 m1_3440_500# iso_tail 0.0015f
C1 iso_p iso_tail 0.05749f
C2 m2_900_1400# m1_1000_500# 0.01113f
C3 m1_3440_500# m2_900_1400# 0.01113f
C4 iso_p m2_900_1400# 0.41846f
C5 m1_3440_500# sense_n 0.04555f
C6 sense_p iso_tail 0.12292f
C7 iso_p m1_1000_500# 0.0015f
C8 sense_p m2_900_1400# 0.04273f
C9 sense_p m1_1000_500# 0.04555f
C10 iso_n iso_tail 0.05717f
C11 sense_p iso_p 0.02157f
C12 iso_n m2_900_1400# 0.41846f
C13 iso_n sense_n 0.02157f
C14 m2_900_1400# iso_tail 0.34398f
C15 sense_n iso_tail 0.11179f
C16 sense_n m2_900_1400# 0.04273f
C17 m1_3440_500# iso_n 0.0015f
C18 iso_p iso_n 0.00782f
C19 m1_1000_500# iso_tail 0.0015f
C20 iso_n VSUBS 1.04634f
C21 iso_p VSUBS 1.04634f
C22 iso_tail VSUBS 4.24257f
C23 m2_900_1400# VSUBS 1.01648f
C24 m1_3440_500# VSUBS 0.31893f
C25 m1_1000_500# VSUBS 0.31893f
.ends

.subckt escaped_input_latch out_p out_n latch_sense_p latch_sense_n tail reset vdd
+ vss eval sense_p sense_n iso_tail vdd_active
X0 out_p out_n vdd_active vdd_active sky130_fd_pr__pfet_01v8 ad=3.36 pd=8 as=3.12 ps=7.6 w=1.2 l=0.6
X1 vdd reset out_n vdd sky130_fd_pr__pfet_01v8 ad=3.12 pd=7.6 as=3.36 ps=8 w=1.2 l=0.6
X2 tail out_p out_n vss sky130_fd_pr__nfet_01v8 ad=3.12 pd=7.6 as=3.36 ps=8 w=1.2 l=0.6
X3 out_p reset vdd vdd sky130_fd_pr__pfet_01v8 ad=3.36 pd=8 as=3.12 ps=7.6 w=1.2 l=0.6
X4 out_p out_n tail vss sky130_fd_pr__nfet_01v8 ad=3.36 pd=8 as=3.12 ps=7.6 w=1.2 l=0.6
X5 tail latch_sense_n out_n vss sky130_fd_pr__nfet_01v8 ad=3.12 pd=7.6 as=3.36 ps=8 w=1.2 l=0.6
X6 tail eval vss vss sky130_fd_pr__nfet_01v8 ad=16.2 pd=17.4 as=16.2 ps=17.4 w=6 l=0.6
X7 out_p latch_sense_p tail vss sky130_fd_pr__nfet_01v8 ad=3.36 pd=8 as=3.12 ps=7.6 w=1.2 l=0.6
X8 iso_tail sense_n latch_sense_n vss sky130_fd_pr__nfet_01v8 ad=3.12 pd=7.6 as=3.36 ps=8 w=1.2 l=0.6
X9 vdd_active out_p out_n vdd_active sky130_fd_pr__pfet_01v8 ad=3.12 pd=7.6 as=3.36 ps=8 w=1.2 l=0.6
X10 latch_sense_p sense_p iso_tail vss sky130_fd_pr__nfet_01v8 ad=3.36 pd=8 as=3.12 ps=7.6 w=1.2 l=0.6
C0 tail latch_sense_n 0.0334f
C1 reset tail 0.16491f
C2 vdd out_n 0.77104f
C3 latch_sense_p tail 0.0334f
C4 reset vdd 4.47121f
C5 vdd_active out_p 3.06556f
C6 out_n latch_sense_n 0.18428f
C7 vdd_active tail 0.9938f
C8 reset out_n 0.31048f
C9 iso_tail latch_sense_n 0.20888f
C10 vdd_active out_n 3.16716f
C11 latch_sense_p iso_tail 0.20888f
C12 sense_n latch_sense_n 0.22977f
C13 out_p tail 0.46979f
C14 sense_p latch_sense_p 0.22977f
C15 out_p vdd 0.76206f
C16 vdd tail 0.9918f
C17 eval tail 0.35666f
C18 sense_n iso_tail 0.10725f
C19 sense_p iso_tail 0.26105f
C20 out_p out_n 2.54301f
C21 reset out_p 0.376f
C22 out_p latch_sense_p 0.18428f
C23 out_n tail 0.46979f
C24 iso_tail vss 29.23796f
C25 latch_sense_n vss 1.7693f
C26 latch_sense_p vss 1.56796f
C27 out_n vss 13.58747f
C28 tail vss 89.03816f
C29 vdd_active vss 90.11912f
C30 vdd vss 78.65506f
.ends

.subckt aimc_converter_macro_active_candidate vss vdd row_drive sar_comparator_input
+ decision_p decision_n reset eval vss_escape latch_sense_p_ext latch_sense_n_ext
+ iso_tail_ext tail_ext vdd_ext preamp_iso_tail_ext
Xphysical_preamp_0 physical_preamp_0/iso_tail physical_preamp_0/iso_p physical_preamp_0/iso_n
+ physical_preamp_0/sense_p physical_preamp_0/sense_n sar_comparator_input row_drive
+ physical_preamp_0/m2_900_1400# vss_escape sky130_transistor_active_isolation_pair
Xconverter_latch_0 decision_p decision_n latch_sense_p_ext latch_sense_n_ext tail_ext
+ reset vdd_ext vss_escape eval row_drive sar_comparator_input iso_tail_ext vdd_ext
+ escaped_input_latch
C0 physical_preamp_0/iso_n vdd_ext 0.0106f
C1 vss vdd_ext 0.20794f
C2 row_drive shared_converter_mux_0/vdd 0.00246f
C3 latch_sense_n_ext vss 0.23329f
C4 physical_preamp_0/sense_n vdd_ext 0.0039f
C5 row_drive shared_converter_mux_0/vss 0.00246f
C6 iso_tail_ext vdd_ext 0.86179f
C7 iso_tail_ext latch_sense_n_ext -0.08311f
C8 m1_69940_2940# preamp_iso_tail_ext 0.03103f
C9 sar_readout_12b_0/vss row_drive 0.29422f
C10 physical_preamp_0/iso_tail sar_comparator_input 0.0361f
C11 row_drive shared_converter_mux_0/mux_bus 0.06281f
C12 row_dac_10b_0/vss row_drive 1.08123f
C13 iso_tail_ext sar_readout_12b_0/vdd 0.27521f
C14 physical_preamp_0/iso_n physical_preamp_0/m2_900_1400# -0
C15 physical_preamp_0/sense_n physical_preamp_0/m2_900_1400# -0.00318f
C16 row_drive physical_preamp_0/iso_tail 0.02322f
C17 physical_preamp_0/iso_p sar_comparator_input 0.02717f
C18 latch_sense_p_ext row_drive 0.01436f
C19 vdd row_drive 0.1964f
C20 physical_preamp_0/iso_p row_drive -0
C21 sar_comparator_input vdd_ext 1.05718f
C22 latch_sense_n_ext sar_comparator_input -0.18697f
C23 tail_ext reset 0.01085f
C24 shared_converter_mux_0/vdd shared_converter_mux_0/mux_bus 1.55306f
C25 row_drive vdd_ext 2.61675f
C26 latch_sense_n_ext row_drive 0.20099f
C27 shared_converter_mux_0/mux_bus shared_converter_mux_0/vss 1.56188f
C28 physical_preamp_0/sense_p vdd_ext 0.03284f
C29 physical_preamp_0/m2_900_1400# sar_comparator_input 0.16477f
C30 row_dac_10b_0/vdd row_drive 1.11462f
C31 row_drive sar_readout_12b_0/vdd 0.57218f
C32 reset vdd_ext 0.01669f
C33 row_drive physical_preamp_0/m2_900_1400# -0.00731f
C34 physical_preamp_0/m2_900_1400# physical_preamp_0/sense_p -0.00637f
C35 tail_ext eval 0.01085f
C36 shared_converter_mux_0/vdd vdd_ext 0
C37 vdd_ext shared_converter_mux_0/vss 0
C38 sar_readout_12b_0/vss vdd_ext 0.93663f
C39 shared_converter_mux_0/mux_bus vdd_ext 0.00217f
C40 physical_preamp_0/iso_n sar_comparator_input 0.027f
C41 physical_preamp_0/sense_n sar_comparator_input 0.02993f
C42 iso_tail_ext sar_comparator_input 0.05996f
C43 sar_readout_12b_0/vss sar_readout_12b_0/vdd 0.49712f
C44 physical_preamp_0/iso_tail vdd_ext 0.30577f
C45 eval vdd_ext 0
C46 latch_sense_p_ext vdd_ext 3.43095f
C47 row_drive vss 0.22445f
C48 row_dac_10b_0/vdd row_dac_10b_0/vss 0.78467f
C49 tail_ext decision_n 0.01085f
C50 iso_tail_ext row_drive 1.71857f
C51 physical_preamp_0/iso_p vdd_ext 0.02484f
C52 tail_ext decision_p 0.01085f
C53 latch_sense_n_ext vdd_ext 3.48444f
C54 physical_preamp_0/iso_p physical_preamp_0/m2_900_1400# 0
C55 shared_converter_mux_0/vdd vss 0.2816f
C56 sar_readout_12b_0/vdd vdd_ext 1.39936f
C57 row_drive sar_comparator_input 5.23145f
C58 physical_preamp_0/sense_p sar_comparator_input 0.04049f
C59 decision_p vdd_ext 0
C60 physical_preamp_0/m2_900_1400# vdd_ext 0.07266f
C61 shared_converter_mux_0/mux_bus vss 0.03132f
C62 sar_readout_12b_0/vss iso_tail_ext 0.60045f
C63 row_drive physical_preamp_0/sense_p 0.03601f
C64 latch_sense_p_ext vss 0.23329f
C65 iso_tail_ext latch_sense_p_ext -0.08311f
C66 preamp_iso_tail_ext vss_escape 0.18641f
C67 vss vss_escape 36.6898f
C68 vdd vss_escape 36.7f
C69 m1_69940_2940# vss_escape 0.19727f ; **FLOATING
C70 iso_tail_ext vss_escape -1.05232f
C71 sar_comparator_input vss_escape 10.26652f
C72 latch_sense_n_ext vss_escape -0.64712f
C73 latch_sense_p_ext vss_escape -0.87822f
C74 decision_n vss_escape 3.8093f
C75 eval vss_escape 0.78348f
C76 row_drive vss_escape 19.0962f
C77 vdd_ext vss_escape 47.37503f
.ends
