* NGSPICE file created from aimc_converter_macro_active_candidate_flat.ext - technology: sky130A

.subckt aimc_converter_macro_active_candidate_flat vss vdd row_drive decision_p decision_n
+ reset eval vss_escape latch_sense_p_ext latch_sense_n_ext iso_tail_ext tail_ext
+ vdd_ext
X0 row_drive physical_preamp_0.sense_n physical_preamp_0.iso_n vss_escape sky130_fd_pr__nfet_01v8 ad=3.12 pd=7.6 as=3.36 ps=8 w=1.2 l=0.6
X1 vdd_ext decision_p decision_n vdd_ext sky130_fd_pr__pfet_01v8 ad=3.12 pd=7.6 as=3.36 ps=8 w=1.2 l=0.6
X2 tail_ext eval vss_escape vss_escape sky130_fd_pr__nfet_01v8 ad=16.2 pd=17.4 as=16.2 ps=17.4 w=6 l=0.6
X3 physical_preamp_0.iso_p physical_preamp_0.sense_p row_drive vss_escape sky130_fd_pr__nfet_01v8 ad=3.36 pd=8 as=3.12 ps=7.6 w=1.2 l=0.6
X4 decision_p latch_sense_p_ext tail_ext vss_escape sky130_fd_pr__nfet_01v8 ad=3.36 pd=8 as=3.12 ps=7.6 w=1.2 l=0.6
X5 vdd_ext reset decision_n vdd_ext sky130_fd_pr__pfet_01v8 ad=3.12 pd=7.6 as=3.36 ps=8 w=1.2 l=0.6
X6 tail_ext latch_sense_n_ext decision_n vss_escape sky130_fd_pr__nfet_01v8 ad=3.12 pd=7.6 as=3.36 ps=8 w=1.2 l=0.6
X7 decision_p decision_n vdd_ext vdd_ext sky130_fd_pr__pfet_01v8 ad=3.36 pd=8 as=3.12 ps=7.6 w=1.2 l=0.6
X8 tail_ext decision_p decision_n vss_escape sky130_fd_pr__nfet_01v8 ad=3.12 pd=7.6 as=3.36 ps=8 w=1.2 l=0.6
X9 latch_sense_p_ext row_drive iso_tail_ext vss_escape sky130_fd_pr__nfet_01v8 ad=3.36 pd=8 as=3.12 ps=7.6 w=1.2 l=0.6
X10 iso_tail_ext row_drive latch_sense_n_ext vss_escape sky130_fd_pr__nfet_01v8 ad=3.12 pd=7.6 as=3.36 ps=8 w=1.2 l=0.6
X11 decision_p reset vdd_ext vdd_ext sky130_fd_pr__pfet_01v8 ad=3.36 pd=8 as=3.12 ps=7.6 w=1.2 l=0.6
X12 decision_p decision_n tail_ext vss_escape sky130_fd_pr__nfet_01v8 ad=3.36 pd=8 as=3.12 ps=7.6 w=1.2 l=0.6
C0 physical_preamp_0.iso_p row_drive 0.55408f
C1 vdd_ext row_drive 5.66178f
C2 sar_readout_12b_0.vdd iso_tail_ext 0.27521f
C3 sar_readout_12b_0.vss vdd_ext 0.93663f
C4 decision_p vdd_ext 3.8282f
C5 latch_sense_p_ext row_drive 0.6214f
C6 latch_sense_n_ext iso_tail_ext 0.12577f
C7 decision_n decision_p 2.54301f
C8 latch_sense_p_ext decision_p 0.18428f
C9 shared_converter_mux_0.vdd vss 0.2816f
C10 decision_p tail_ext 0.48065f
C11 shared_converter_mux_0.mux_bus vdd_ext 0.00217f
C12 physical_preamp_0.sense_p row_drive 0.4161f
C13 shared_converter_mux_0.vss vdd_ext 0
C14 latch_sense_n_ext vss 0.23329f
C15 eval vdd_ext 0
C16 iso_tail_ext row_drive 2.56426f
C17 sar_readout_12b_0.vss iso_tail_ext 0.60045f
C18 physical_preamp_0.iso_p physical_preamp_0.iso_n 0.00782f
C19 shared_converter_mux_0.vdd row_drive 0.00246f
C20 vdd_ext physical_preamp_0.iso_n 0.0106f
C21 physical_preamp_0.iso_p li_67560_2680# 0
C22 sar_readout_12b_0.vdd row_drive 0.58157f
C23 vdd_ext li_67560_2680# 0.5788f
C24 sar_readout_12b_0.vss sar_readout_12b_0.vdd 0.49712f
C25 eval tail_ext 0.36751f
C26 physical_preamp_0.sense_n vdd_ext 0.00811f
C27 latch_sense_n_ext row_drive 0.62025f
C28 vss row_drive 0.22445f
C29 shared_converter_mux_0.vdd shared_converter_mux_0.mux_bus 1.55306f
C30 physical_preamp_0.sense_p li_67560_2680# 0
C31 vdd_ext reset 4.48789f
C32 shared_converter_mux_0.mux_bus vss 0.03132f
C33 decision_n reset 0.31048f
C34 row_dac_10b_0.vss row_drive 1.08123f
C35 sar_readout_12b_0.vss row_drive 0.29433f
C36 tail_ext reset 0.17577f
C37 shared_converter_mux_0.mux_bus row_drive 0.06281f
C38 shared_converter_mux_0.vss row_drive 0.00246f
C39 row_dac_10b_0.vss row_dac_10b_0.vdd 0.78467f
C40 row_dac_10b_0.vdd row_drive 1.11462f
C41 vdd row_drive 0.1964f
C42 vdd_ext physical_preamp_0.iso_p 0.02433f
C43 physical_preamp_0.iso_n row_drive 0.53283f
C44 li_67560_2680# row_drive 3.1653f
C45 decision_n vdd_ext 3.9382f
C46 latch_sense_p_ext vdd_ext 3.43095f
C47 shared_converter_mux_0.vss shared_converter_mux_0.mux_bus 1.56188f
C48 vdd_ext tail_ext 1.9856f
C49 physical_preamp_0.sense_n row_drive 0.34447f
C50 decision_n tail_ext 0.48065f
C51 latch_sense_p_ext tail_ext 0.0334f
C52 physical_preamp_0.sense_p physical_preamp_0.iso_p 0.00681f
C53 physical_preamp_0.sense_p vdd_ext 0.00783f
C54 vdd_ext iso_tail_ext 0.86179f
C55 decision_p reset 0.376f
C56 shared_converter_mux_0.vdd vdd_ext 0
C57 sar_readout_12b_0.vdd vdd_ext 1.39936f
C58 latch_sense_p_ext iso_tail_ext 0.12577f
C59 physical_preamp_0.iso_n li_67560_2680# 0
C60 latch_sense_n_ext vdd_ext 3.48444f
C61 vdd_ext vss 0.21361f
C62 physical_preamp_0.sense_n physical_preamp_0.iso_n 0.02157f
C63 physical_preamp_0.sense_n li_67560_2680# 0.1057f
C64 decision_n latch_sense_n_ext 0.18428f
C65 latch_sense_p_ext vss 0.23329f
C66 latch_sense_n_ext tail_ext 0.0334f
C67 vss vss_escape 36.2211f
C68 vdd vss_escape 36.7f
C69 iso_tail_ext vss_escape 69.16672f
C70 latch_sense_p_ext vss_escape 48.19852f
C71 decision_p vss_escape 7.38983f
C72 tail_ext vss_escape 81.08725f
C73 vdd_ext vss_escape 0.2587p
C74 sar_readout_12b_0.vss vss_escape 1.33686f ; **FLOATING
C75 row_dac_10b_0.vss vss_escape 1.40333f ; **FLOATING
C76 row_dac_10b_0.vdd vss_escape 1.33457f ; **FLOATING
C77 sar_readout_12b_0.vdd vss_escape 1.77614f ; **FLOATING
C78 shared_converter_mux_0.vss vss_escape 1.39454f ; **FLOATING
C79 shared_converter_mux_0.mux_bus vss_escape 2.86922f ; **FLOATING
C80 shared_converter_mux_0.vdd vss_escape 0.95985f ; **FLOATING
C81 li_67560_2680# vss_escape 9.26056f ; **FLOATING
C82 physical_preamp_0.iso_n vss_escape 1.18745f
C83 physical_preamp_0.iso_p vss_escape 1.00841f
.ends
