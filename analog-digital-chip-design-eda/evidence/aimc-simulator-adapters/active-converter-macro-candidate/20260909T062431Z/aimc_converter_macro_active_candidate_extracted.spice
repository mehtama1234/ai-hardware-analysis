* NGSPICE file created from aimc_converter_macro_active_candidate.ext - technology: sky130A

.subckt escaped_input_latch out_p out_n latch_sense_p latch_sense_n tail reset vdd
+ vss eval sense_p sense_n iso_tail vdd_active
X0 out_p out_n vdd_active vdd_active sky130_fd_pr__pfet_01v8 ad=6.72 pd=10.4 as=6.24 ps=10 w=2.4 l=0.6
X1 vdd reset out_n vdd sky130_fd_pr__pfet_01v8 ad=3.12 pd=7.6 as=3.36 ps=8 w=1.2 l=0.6
X2 tail out_p out_n vss sky130_fd_pr__nfet_01v8 ad=12.48 pd=14.8 as=13.44 ps=15.2 w=4.8 l=0.6
X3 out_p reset vdd vdd sky130_fd_pr__pfet_01v8 ad=3.36 pd=8 as=3.12 ps=7.6 w=1.2 l=0.6
X4 out_p out_n tail vss sky130_fd_pr__nfet_01v8 ad=13.44 pd=15.2 as=12.48 ps=14.8 w=4.8 l=0.6
X5 tail latch_sense_n out_n vss sky130_fd_pr__nfet_01v8 ad=12.48 pd=14.8 as=13.44 ps=15.2 w=4.8 l=0.6
X6 tail eval vss vss sky130_fd_pr__nfet_01v8 ad=16.2 pd=17.4 as=16.2 ps=17.4 w=6 l=0.6
X7 out_p latch_sense_p tail vss sky130_fd_pr__nfet_01v8 ad=13.44 pd=15.2 as=12.48 ps=14.8 w=4.8 l=0.6
X8 iso_tail sense_n latch_sense_n vss sky130_fd_pr__nfet_01v8 ad=3.12 pd=7.6 as=3.36 ps=8 w=1.2 l=0.6
X9 vdd_active out_p out_n vdd_active sky130_fd_pr__pfet_01v8 ad=6.24 pd=10 as=6.72 ps=10.4 w=2.4 l=0.6
X10 latch_sense_p sense_p iso_tail vss sky130_fd_pr__nfet_01v8 ad=3.36 pd=8 as=3.12 ps=7.6 w=1.2 l=0.6
C0 out_p tail 0.51868f
C1 sense_p latch_sense_p 0.22977f
C2 latch_sense_n sense_n 0.22977f
C3 out_n vdd 0.77104f
C4 vdd_active tail 0.9938f
C5 out_p out_n 2.60132f
C6 out_p vdd 0.76206f
C7 iso_tail sense_p 0.26105f
C8 iso_tail sense_n 0.10725f
C9 out_n vdd_active 2.93626f
C10 latch_sense_p tail 0.0334f
C11 latch_sense_n tail 0.0334f
C12 reset tail 0.16491f
C13 out_p vdd_active 2.83065f
C14 iso_tail latch_sense_p 0.20888f
C15 latch_sense_n iso_tail 0.20888f
C16 eval tail 0.35666f
C17 latch_sense_n out_n 0.1874f
C18 out_n reset 0.31048f
C19 reset vdd 4.47121f
C20 out_p latch_sense_p 0.1874f
C21 out_p reset 0.376f
C22 out_n tail 0.51868f
C23 vdd tail 0.9918f
C24 iso_tail vss 29.23796f
C25 latch_sense_n vss 1.7693f
C26 latch_sense_p vss 1.56796f
C27 out_n vss 12.9274f
C28 tail vss 86.83939f
C29 vdd_active vss 89.13274f
C30 vdd vss 78.65506f
.ends

.subckt aimc_converter_macro_active_candidate vss vdd row_drive sar_comparator_input
+ decision_p decision_n reset eval vss_escape latch_sense_p_ext latch_sense_n_ext
+ iso_tail_ext tail_ext vdd_ext
Xconverter_latch_0 decision_p decision_n latch_sense_p_ext latch_sense_n_ext tail_ext
+ reset vdd_ext vss_escape eval row_drive sar_comparator_input iso_tail_ext vdd_ext
+ escaped_input_latch
C0 row_drive shared_converter_mux_0/vdd 0.00246f
C1 row_drive row_dac_10b_0/vdd 1.11409f
C2 vdd_ext shared_converter_mux_0/vdd 0
C3 reset tail_ext 0.01085f
C4 row_drive vdd 0.1964f
C5 decision_n tail_ext 0.01085f
C6 row_drive iso_tail_ext 0.26323f
C7 sar_readout_12b_0/vss iso_tail_ext 0.60149f
C8 vdd_ext iso_tail_ext 0.31557f
C9 vdd_ext reset 0.01669f
C10 shared_converter_mux_0/vss shared_converter_mux_0/mux_bus 1.56188f
C11 vss latch_sense_p_ext 0.23329f
C12 latch_sense_n_ext vss 0.23329f
C13 row_drive latch_sense_p_ext 0
C14 row_drive sar_readout_12b_0/vdd 0.33461f
C15 sar_readout_12b_0/vdd sar_readout_12b_0/vss 0.49712f
C16 vdd_ext sar_readout_12b_0/vdd 1.39936f
C17 vss shared_converter_mux_0/mux_bus 0.03132f
C18 row_drive row_dac_10b_0/vss 1.08123f
C19 row_drive shared_converter_mux_0/mux_bus 0.06281f
C20 tail_ext decision_p 0.01085f
C21 row_drive shared_converter_mux_0/vss 0.00246f
C22 vdd_ext shared_converter_mux_0/mux_bus 0.00217f
C23 shared_converter_mux_0/vss vdd_ext 0
C24 vdd_ext decision_p 0
C25 sar_readout_12b_0/vdd iso_tail_ext 0.27625f
C26 shared_converter_mux_0/vdd shared_converter_mux_0/mux_bus 1.55306f
C27 sar_comparator_input iso_tail_ext 0.08712f
C28 row_dac_10b_0/vdd row_dac_10b_0/vss 0.78467f
C29 row_drive vss 0.22445f
C30 vdd_ext vss 0.19458f
C31 row_drive sar_readout_12b_0/vss 0.21493f
C32 row_drive vdd_ext 1.55835f
C33 vdd_ext sar_readout_12b_0/vss 0.93663f
C34 tail_ext eval 0.01085f
C35 vss shared_converter_mux_0/vdd 0.2816f
C36 vdd_ext eval 0
C37 vss vss_escape 30.5941f
C38 vdd vss_escape 30.5941f
C39 iso_tail_ext vss_escape -0.88568f
C40 sar_comparator_input vss_escape 1.15812f
C41 decision_n vss_escape 3.8093f
C42 eval vss_escape 0.78348f
C43 row_drive vss_escape 7.1806f
C44 vdd_ext vss_escape 34.16415f
.ends
