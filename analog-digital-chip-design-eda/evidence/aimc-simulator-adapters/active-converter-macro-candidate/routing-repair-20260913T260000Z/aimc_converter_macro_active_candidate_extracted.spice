* NGSPICE file created from aimc_converter_macro_active_candidate_flat.ext - technology: sky130A

.subckt aimc_converter_macro_active_candidate_flat vss vdd row_drive sar_comparator_input
+ decision_p decision_n reset eval vss_escape latch_sense_p_ext latch_sense_n_ext
+ iso_tail_ext tail_ext vdd_ext
X0 physical_preamp_0.preamp_iso_tail_ext physical_preamp_0.sar_comparator_input physical_preamp_0.latch_sense_n_ext vss_escape sky130_fd_pr__nfet_01v8 ad=3.12 pd=7.6 as=3.36 ps=8 w=1.2 l=0.6
X1 vdd_ext decision_p decision_n vdd_ext sky130_fd_pr__pfet_01v8 ad=3.12 pd=7.6 as=3.36 ps=8 w=1.2 l=0.6
X2 tail_ext eval vss_escape vss_escape sky130_fd_pr__nfet_01v8 ad=16.2 pd=17.4 as=16.2 ps=17.4 w=6 l=0.6
X3 physical_preamp_0.latch_sense_p_ext physical_preamp_0.row_drive physical_preamp_0.preamp_iso_tail_ext vss_escape sky130_fd_pr__nfet_01v8 ad=3.36 pd=8 as=3.12 ps=7.6 w=1.2 l=0.6
X4 decision_p latch_sense_p_ext tail_ext vss_escape sky130_fd_pr__nfet_01v8 ad=3.36 pd=8 as=3.12 ps=7.6 w=1.2 l=0.6
X5 vdd_ext reset decision_n vdd_ext sky130_fd_pr__pfet_01v8 ad=3.12 pd=7.6 as=3.36 ps=8 w=1.2 l=0.6
X6 tail_ext latch_sense_n_ext decision_n vss_escape sky130_fd_pr__nfet_01v8 ad=3.12 pd=7.6 as=3.36 ps=8 w=1.2 l=0.6
X7 decision_p decision_n vdd_ext vdd_ext sky130_fd_pr__pfet_01v8 ad=3.36 pd=8 as=3.12 ps=7.6 w=1.2 l=0.6
X8 tail_ext decision_p decision_n vss_escape sky130_fd_pr__nfet_01v8 ad=3.12 pd=7.6 as=3.36 ps=8 w=1.2 l=0.6
X9 latch_sense_p_ext row_drive iso_tail_ext vss_escape sky130_fd_pr__nfet_01v8 ad=3.36 pd=8 as=3.12 ps=7.6 w=1.2 l=0.6
X10 iso_tail_ext sar_comparator_input latch_sense_n_ext vss_escape sky130_fd_pr__nfet_01v8 ad=3.12 pd=7.6 as=3.36 ps=8 w=1.2 l=0.6
X11 decision_p reset vdd_ext vdd_ext sky130_fd_pr__pfet_01v8 ad=3.36 pd=8 as=3.12 ps=7.6 w=1.2 l=0.6
X12 decision_p decision_n tail_ext vss_escape sky130_fd_pr__nfet_01v8 ad=3.36 pd=8 as=3.12 ps=7.6 w=1.2 l=0.6
C0 iso_tail_ext latch_sense_n_ext 0.12577f
C1 row_dac_10b_0.vss row_drive 1.08123f
C2 vss row_drive 0.22445f
C3 vdd_ext shared_converter_mux_0.vss 0
C4 latch_sense_n_ext tail_ext 0.0334f
C5 vdd_ext iso_tail_ext 0.86179f
C6 physical_preamp_0.row_drive m1_68300_3080# 0
C7 physical_preamp_0.latch_sense_n_ext sar_comparator_input 0.0285f
C8 physical_preamp_0.row_drive m2_64900_1400# 0.03637f
C9 vdd_ext tail_ext 1.9856f
C10 decision_p tail_ext 0.48065f
C11 vdd_ext latch_sense_n_ext 3.48444f
C12 sar_comparator_input row_drive 5.24644f
C13 vdd_ext physical_preamp_0.latch_sense_p_ext 0.01996f
C14 decision_n reset 0.31048f
C15 latch_sense_p_ext row_drive 0.6214f
C16 physical_preamp_0.preamp_iso_tail_ext sar_comparator_input 0.03759f
C17 shared_converter_mux_0.mux_bus shared_converter_mux_0.vss 1.56188f
C18 physical_preamp_0.latch_sense_n_ext physical_preamp_0.sar_comparator_input 0.02157f
C19 physical_preamp_0.latch_sense_n_ext m1_68300_3080# 0
C20 vdd_ext decision_p 3.8282f
C21 sar_readout_12b_0.vss iso_tail_ext 0.60045f
C22 m2_64900_1400# physical_preamp_0.latch_sense_n_ext 0.41846f
C23 physical_preamp_0.sar_comparator_input row_drive 0.01038f
C24 tail_ext eval 0.36751f
C25 m1_68300_3080# row_drive 2.68328f
C26 physical_preamp_0.sar_comparator_input physical_preamp_0.preamp_iso_tail_ext 0.11179f
C27 m1_68300_3080# physical_preamp_0.preamp_iso_tail_ext 0.01748f
C28 m2_64900_1400# row_drive 0.01396f
C29 physical_preamp_0.row_drive physical_preamp_0.latch_sense_p_ext 0.02157f
C30 m2_64900_1400# physical_preamp_0.preamp_iso_tail_ext 0.34398f
C31 row_dac_10b_0.vdd row_drive 1.11462f
C32 vss latch_sense_p_ext 0.23329f
C33 shared_converter_mux_0.vdd vdd_ext 0
C34 vdd_ext eval 0
C35 shared_converter_mux_0.mux_bus vdd_ext 0.00217f
C36 physical_preamp_0.row_drive vdd_ext 0.0297f
C37 sar_readout_12b_0.vdd iso_tail_ext 0.27521f
C38 shared_converter_mux_0.vss row_drive 0.00246f
C39 vdd_ext sar_readout_12b_0.vss 0.93663f
C40 iso_tail_ext row_drive 2.39704f
C41 reset tail_ext 0.17577f
C42 physical_preamp_0.latch_sense_n_ext physical_preamp_0.latch_sense_p_ext 0.00782f
C43 latch_sense_n_ext row_drive 0.57746f
C44 shared_converter_mux_0.mux_bus shared_converter_mux_0.vdd 1.55306f
C45 physical_preamp_0.latch_sense_p_ext row_drive 0.00608f
C46 row_dac_10b_0.vdd row_dac_10b_0.vss 0.78467f
C47 vdd_ext reset 4.48789f
C48 physical_preamp_0.latch_sense_n_ext vdd_ext 0.00673f
C49 physical_preamp_0.latch_sense_p_ext physical_preamp_0.preamp_iso_tail_ext 0.05749f
C50 decision_p reset 0.376f
C51 vdd_ext sar_readout_12b_0.vdd 1.39936f
C52 vdd row_drive 0.1964f
C53 vdd_ext row_drive 3.82717f
C54 physical_preamp_0.sar_comparator_input sar_comparator_input 0.07548f
C55 vdd_ext physical_preamp_0.preamp_iso_tail_ext 0.18336f
C56 m2_64900_1400# sar_comparator_input 0.1759f
C57 vss latch_sense_n_ext 0.23329f
C58 m1_68300_3080# physical_preamp_0.sar_comparator_input 0
C59 shared_converter_mux_0.vdd row_drive 0.00246f
C60 shared_converter_mux_0.mux_bus row_drive 0.06281f
C61 sar_readout_12b_0.vss sar_readout_12b_0.vdd 0.49712f
C62 physical_preamp_0.row_drive row_drive 0.09195f
C63 m2_64900_1400# physical_preamp_0.sar_comparator_input 0.03955f
C64 iso_tail_ext sar_comparator_input 0.16721f
C65 m2_64900_1400# m1_68300_3080# 0
C66 iso_tail_ext latch_sense_p_ext 0.12577f
C67 sar_readout_12b_0.vss row_drive 0.29433f
C68 physical_preamp_0.row_drive physical_preamp_0.preamp_iso_tail_ext 0.12292f
C69 vdd_ext vss 0.19458f
C70 latch_sense_p_ext tail_ext 0.0334f
C71 latch_sense_n_ext sar_comparator_input 0.04279f
C72 physical_preamp_0.latch_sense_p_ext sar_comparator_input 0.02717f
C73 decision_n tail_ext 0.48065f
C74 latch_sense_n_ext decision_n 0.18428f
C75 physical_preamp_0.latch_sense_n_ext row_drive 0.00475f
C76 vdd_ext sar_comparator_input 1.05659f
C77 shared_converter_mux_0.vdd vss 0.2816f
C78 physical_preamp_0.latch_sense_n_ext physical_preamp_0.preamp_iso_tail_ext 0.05717f
C79 sar_readout_12b_0.vdd row_drive 0.58157f
C80 vdd_ext latch_sense_p_ext 3.43095f
C81 shared_converter_mux_0.mux_bus vss 0.03132f
C82 latch_sense_p_ext decision_p 0.18428f
C83 physical_preamp_0.preamp_iso_tail_ext row_drive 0.23369f
C84 physical_preamp_0.latch_sense_p_ext m1_68300_3080# 0
C85 vdd_ext decision_n 3.9382f
C86 decision_n decision_p 2.54301f
C87 m2_64900_1400# physical_preamp_0.latch_sense_p_ext 0.41846f
C88 vdd_ext physical_preamp_0.sar_comparator_input 0.0031f
C89 vdd_ext m1_68300_3080# 0.24419f
C90 m2_64900_1400# vdd_ext 0.06307f
C91 physical_preamp_0.row_drive sar_comparator_input 0.04049f
C92 vss vss_escape 36.2292f
C93 vdd vss_escape 36.7f
C94 iso_tail_ext vss_escape 65.8989f
C95 latch_sense_n_ext vss_escape 8.9128f
C96 latch_sense_p_ext vss_escape 36.0179f
C97 decision_p vss_escape 7.38983f
C98 tail_ext vss_escape 81.08725f
C99 vdd_ext vss_escape 0.2571p
C100 m2_64900_1400# vss_escape 0.72762f ; **FLOATING
C101 sar_readout_12b_0.vss vss_escape 1.33686f ; **FLOATING
C102 row_dac_10b_0.vss vss_escape 1.40333f ; **FLOATING
C103 row_dac_10b_0.vdd vss_escape 1.33457f ; **FLOATING
C104 sar_readout_12b_0.vdd vss_escape 1.77614f ; **FLOATING
C105 m1_68300_3080# vss_escape 7.90194f ; **FLOATING
C106 shared_converter_mux_0.vss vss_escape 1.39454f ; **FLOATING
C107 shared_converter_mux_0.mux_bus vss_escape 2.86922f ; **FLOATING
C108 shared_converter_mux_0.vdd vss_escape 0.95985f ; **FLOATING
C109 physical_preamp_0.latch_sense_n_ext vss_escape 1.04634f
C110 physical_preamp_0.latch_sense_p_ext vss_escape 1.04634f
C111 physical_preamp_0.preamp_iso_tail_ext vss_escape 4.21525f
.ends
