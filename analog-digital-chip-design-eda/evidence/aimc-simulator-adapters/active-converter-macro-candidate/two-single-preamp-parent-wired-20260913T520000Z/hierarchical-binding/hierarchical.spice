* SPICE3 file created from aimc_converter_macro_active_candidate.ext - technology: sky130A

.subckt preamp_n_parent_bound preamp_iso_tail_ext latch_sense_n_ext sar_comparator_input
+ vss_escape
X0 latch_sense_n_ext sar_comparator_input preamp_iso_tail_ext vss_escape sky130_fd_pr__nfet_01v8 ad=3.36 pd=8 as=3.12 ps=7.6 w=1.2 l=0.6
C0 sar_comparator_input preamp_iso_tail_ext 0.02892f
C1 sar_comparator_input latch_sense_n_ext 0.02459f
C2 preamp_iso_tail_ext latch_sense_n_ext 0.03982f
C3 latch_sense_n_ext vss_escape 1.37396f
C4 preamp_iso_tail_ext vss_escape 1.3736f
.ends

.subckt preamp_p_parent_bound preamp_iso_tail_ext latch_sense_p_ext row_drive vss_escape
X0 latch_sense_p_ext row_drive preamp_iso_tail_ext vss_escape sky130_fd_pr__nfet_01v8 ad=3.36 pd=8 as=3.12 ps=7.6 w=1.2 l=0.6
C0 preamp_iso_tail_ext latch_sense_p_ext 0.03982f
C1 preamp_iso_tail_ext row_drive 0.02892f
C2 row_drive latch_sense_p_ext 0.02459f
C3 latch_sense_p_ext vss_escape 1.37396f
C4 preamp_iso_tail_ext vss_escape 1.3736f
.ends

.subckt escaped_input_latch out_p out_n latch_sense_p latch_sense_n tail reset vdd
+ vss eval sense_p sense_n iso_tail vdd_active
X0 out_p out_n vdd_active vdd_active sky130_fd_pr__pfet_01v8 ad=3.36 pd=8 as=3.12 ps=7.6 w=1.2 l=0.6
X1 vdd reset out_n vdd sky130_fd_pr__pfet_01v8 ad=3.12 pd=7.6 as=3.36 ps=8 w=1.2 l=0.6
X2 tail out_p out_n vss sky130_fd_pr__nfet_01v8 ad=3.12 pd=7.6 as=3.36 ps=8 w=1.2 l=0.6
X3 out_p reset vdd vdd sky130_fd_pr__pfet_01v8 ad=3.36 pd=8 as=3.12 ps=7.6 w=1.2 l=0.6
X4 out_p out_n tail vss sky130_fd_pr__nfet_01v8 ad=3.36 pd=8 as=3.12 ps=7.6 w=1.2 l=0.6
X5 tail latch_sense_n out_n vss sky130_fd_pr__nfet_01v8 ad=3.12 pd=7.6 as=3.36 ps=8 w=1.2 l=0.6
X6 tail eval vss vss sky130_fd_pr__nfet_01v8 ad=16.2 pd=17.4 as=16.2 ps=17.4 w=6 l=0.6
X7 out_p latch_sense_p tail vss sky130_fd_pr__nfet_01v8 ad=3.36 pd=8 as=3.12 ps=7.6 w=1.2 l=0.6
X8 iso_tail sense_n latch_sense_n vss sky130_fd_pr__nfet_01v8 ad=3.12 pd=7.6 as=3.36 ps=8 w=1.2 l=0.6
X9 vdd_active out_p out_n vdd_active sky130_fd_pr__pfet_01v8 ad=3.12 pd=7.6 as=3.36 ps=8 w=1.2 l=0.6
X10 latch_sense_p sense_p iso_tail vss sky130_fd_pr__nfet_01v8 ad=3.36 pd=8 as=3.12 ps=7.6 w=1.2 l=0.6
C0 out_p latch_sense_p 0.18428f
C1 reset tail 0.16491f
C2 latch_sense_n tail 0.0334f
C3 vdd_active tail 0.9938f
C4 out_p out_n 2.54301f
C5 vdd out_p 0.76206f
C6 tail latch_sense_p 0.0334f
C7 tail eval 0.35666f
C8 tail out_n 0.46979f
C9 reset out_n 0.31048f
C10 latch_sense_n out_n 0.18428f
C11 vdd_active out_n 3.16716f
C12 reset vdd 4.47121f
C13 vdd tail 0.9918f
C14 sense_p latch_sense_p 0.22977f
C15 sense_n iso_tail 0.10725f
C16 vdd out_n 0.77104f
C17 latch_sense_n iso_tail 0.20888f
C18 latch_sense_n sense_n 0.22977f
C19 out_p tail 0.46979f
C20 sense_p iso_tail 0.26105f
C21 reset out_p 0.376f
C22 vdd_active out_p 3.06556f
C23 iso_tail latch_sense_p 0.20888f
C24 iso_tail vss 29.23796f
C25 latch_sense_n vss 1.7693f
C26 latch_sense_p vss 1.56796f
C27 out_n vss 13.58747f
C28 tail vss 89.03816f
C29 vdd_active vss 90.11912f
C30 vdd vss 78.65506f
.ends

.subckt aimc_converter_macro_active_candidate vss vdd row_drive sar_comparator_input
+ decision_p decision_n reset eval latch_sense_p_ext latch_sense_n_ext iso_tail_ext
+ tail_ext vdd_ext preamp_iso_tail_ext vss_escape_uq1
Xphysical_preamp_n physical_preamp_n/preamp_iso_tail_ext physical_preamp_n/latch_sense_n_ext
+ physical_preamp_n/sar_comparator_input vss_escape_uq1 preamp_n_parent_bound
Xphysical_preamp_p physical_preamp_p/preamp_iso_tail_ext physical_preamp_p/latch_sense_p_ext
+ physical_preamp_p/row_drive vss_escape_uq1 preamp_p_parent_bound
Xconverter_latch_0 decision_p decision_n latch_sense_p_ext latch_sense_n_ext tail_ext
+ reset vdd_ext vss_escape_uq1 eval row_drive sar_comparator_input iso_tail_ext vdd_ext
+ escaped_input_latch
C0 sar_comparator_input latch_sense_n_ext 0.39015f
C1 sar_readout_12b_0/vdd row_drive 0.58157f
C2 latch_sense_n_ext row_drive 0.79612f
C3 vdd_ext sar_readout_12b_0/vss 0.93663f
C4 vdd_ext shared_converter_mux_0/mux_bus 0.00217f
C5 sar_comparator_input latch_sense_p_ext 0.07904f
C6 latch_sense_p_ext eval 0.19752f
C7 iso_tail_ext vdd_ext 0.86179f
C8 vdd_ext m4_45060_36440# 0.01404f
C9 latch_sense_p_ext row_drive 1.03568f
C10 vdd_ext shared_converter_mux_0/vdd 0
C11 latch_sense_p_ext latch_sense_n_ext 0.58447f
C12 latch_sense_p_ext decision_p 0.19207f
C13 row_drive sar_readout_12b_0/vss 0.29433f
C14 row_drive shared_converter_mux_0/mux_bus 0.06281f
C15 sar_comparator_input iso_tail_ext 0.05996f
C16 sar_comparator_input m4_45060_36440# 0.05954f
C17 vdd row_drive 0.1964f
C18 sar_readout_12b_0/vdd sar_readout_12b_0/vss 0.49712f
C19 iso_tail_ext row_drive 2.13599f
C20 row_drive m4_45060_36440# 0.07138f
C21 tail_ext eval 0.01085f
C22 row_drive shared_converter_mux_0/vdd 0.00246f
C23 sar_readout_12b_0/vdd iso_tail_ext 0.27521f
C24 iso_tail_ext latch_sense_n_ext -0.07889f
C25 preamp_iso_tail_ext vdd_ext 0.00145f
C26 tail_ext latch_sense_n_ext 1.06262f
C27 decision_p tail_ext 0.01085f
C28 row_dac_10b_0/vss row_dac_10b_0/vdd 0.78467f
C29 latch_sense_p_ext iso_tail_ext -0.07937f
C30 latch_sense_p_ext m4_45060_36440# 0.00631f
C31 latch_sense_n_ext m4_32000_38940# 0.0096f
C32 latch_sense_p_ext tail_ext 0.96249f
C33 shared_converter_mux_0/vss vdd_ext 0
C34 latch_sense_p_ext m4_32000_38940# 0.00354f
C35 sar_comparator_input preamp_iso_tail_ext 0.01404f
C36 preamp_iso_tail_ext row_drive 0.00432f
C37 iso_tail_ext sar_readout_12b_0/vss 0.60045f
C38 shared_converter_mux_0/vdd shared_converter_mux_0/mux_bus 1.55306f
C39 reset vdd_ext 0.01669f
C40 preamp_iso_tail_ext latch_sense_n_ext 0.25914f
C41 vss vdd_ext 0.19458f
C42 latch_sense_p_ext preamp_iso_tail_ext 0.17162f
C43 shared_converter_mux_0/vss row_drive 0.00246f
C44 m2_42000_41940# row_drive 0.12051f
C45 row_dac_10b_0/vdd row_drive 1.11462f
C46 vdd_ext m1_68300_3080# 0.24419f
C47 decision_n sar_comparator_input 0.17131f
C48 vss sar_comparator_input 0.05708f
C49 vss row_drive 0.22445f
C50 decision_n latch_sense_n_ext 0.19207f
C51 vss latch_sense_n_ext 0.29037f
C52 row_dac_10b_0/vss row_drive 1.08123f
C53 reset latch_sense_p_ext 0.19529f
C54 sar_comparator_input m1_68300_3080# 0.05195f
C55 vss latch_sense_p_ext 0.29037f
C56 shared_converter_mux_0/vss shared_converter_mux_0/mux_bus 1.56188f
C57 row_drive m1_68300_3080# 2.68328f
C58 sar_comparator_input vdd_ext 1.72288f
C59 eval vdd_ext 0
C60 row_drive vdd_ext 4.95644f
C61 vss shared_converter_mux_0/mux_bus 0.03132f
C62 sar_readout_12b_0/vdd vdd_ext 1.39936f
C63 latch_sense_n_ext vdd_ext 4.54014f
C64 decision_p vdd_ext 0
C65 reset tail_ext 0.01085f
C66 decision_n tail_ext 0.01085f
C67 vss shared_converter_mux_0/vdd 0.2816f
C68 latch_sense_p_ext vdd_ext 5.37086f
C69 sar_comparator_input row_drive 5.4563f
C70 vss vss_escape_uq1 36.7f
C71 preamp_iso_tail_ext vss_escape_uq1 4.44855f
C72 vdd vss_escape_uq1 36.7f
C73 m4_45060_36440# vss_escape_uq1 0.09654f **FLOATING
C74 m4_32000_38940# vss_escape_uq1 0.1568f **FLOATING
C75 m2_42000_41940# vss_escape_uq1 3.91591f **FLOATING
C76 m1_68300_3080# vss_escape_uq1 7.89552f **FLOATING
C77 iso_tail_ext vss_escape_uq1 -1.23816f
C78 sar_comparator_input vss_escape_uq1 29.28228f
C79 latch_sense_n_ext vss_escape_uq1 8.3977f
C80 latch_sense_p_ext vss_escape_uq1 11.20863f
C81 decision_n vss_escape_uq1 3.8093f
C82 eval vss_escape_uq1 0.78348f
C83 row_drive vss_escape_uq1 65.2568f
C84 vdd_ext vss_escape_uq1 40.12473f
.ends
