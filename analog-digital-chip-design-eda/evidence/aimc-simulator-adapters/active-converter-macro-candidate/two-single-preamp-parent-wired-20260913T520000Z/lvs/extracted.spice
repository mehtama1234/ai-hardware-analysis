* NGSPICE file created from aimc_converter_macro_active_candidate_flat.ext - technology: sky130A

.subckt aimc_converter_macro_active_candidate_flat vss vdd row_drive sar_comparator_input
+ decision_p decision_n reset eval vss_escape latch_sense_p_ext latch_sense_n_ext
+ iso_tail_ext tail_ext vdd_ext preamp_iso_tail_ext
X0 latch_sense_n_ext sar_comparator_input preamp_iso_tail_ext vss_escape sky130_fd_pr__nfet_01v8 ad=3.36 pd=8 as=3.12 ps=7.6 w=1.2 l=0.6
X1 vdd_ext decision_p decision_n vdd_ext sky130_fd_pr__pfet_01v8 ad=3.12 pd=7.6 as=3.36 ps=8 w=1.2 l=0.6
X2 tail_ext eval vss_escape vss_escape sky130_fd_pr__nfet_01v8 ad=16.2 pd=17.4 as=16.2 ps=17.4 w=6 l=0.6
X3 decision_p latch_sense_p_ext tail_ext vss_escape sky130_fd_pr__nfet_01v8 ad=3.36 pd=8 as=3.12 ps=7.6 w=1.2 l=0.6
X4 vdd_ext reset decision_n vdd_ext sky130_fd_pr__pfet_01v8 ad=3.12 pd=7.6 as=3.36 ps=8 w=1.2 l=0.6
X5 tail_ext latch_sense_n_ext decision_n vss_escape sky130_fd_pr__nfet_01v8 ad=3.12 pd=7.6 as=3.36 ps=8 w=1.2 l=0.6
X6 decision_p decision_n vdd_ext vdd_ext sky130_fd_pr__pfet_01v8 ad=3.36 pd=8 as=3.12 ps=7.6 w=1.2 l=0.6
X7 tail_ext decision_p decision_n vss_escape sky130_fd_pr__nfet_01v8 ad=3.12 pd=7.6 as=3.36 ps=8 w=1.2 l=0.6
X8 latch_sense_p_ext row_drive iso_tail_ext vss_escape sky130_fd_pr__nfet_01v8 ad=3.36 pd=8 as=3.12 ps=7.6 w=1.2 l=0.6
X9 iso_tail_ext sar_comparator_input latch_sense_n_ext vss_escape sky130_fd_pr__nfet_01v8 ad=3.12 pd=7.6 as=3.36 ps=8 w=1.2 l=0.6
X10 latch_sense_p_ext row_drive preamp_iso_tail_ext vss_escape sky130_fd_pr__nfet_01v8 ad=3.36 pd=8 as=3.12 ps=7.6 w=1.2 l=0.6
X11 decision_p reset vdd_ext vdd_ext sky130_fd_pr__pfet_01v8 ad=3.36 pd=8 as=3.12 ps=7.6 w=1.2 l=0.6
X12 decision_p decision_n tail_ext vss_escape sky130_fd_pr__nfet_01v8 ad=3.36 pd=8 as=3.12 ps=7.6 w=1.2 l=0.6
C0 vdd_ext decision_n 3.9382f
C1 vdd_ext tail_ext 1.9856f
C2 row_dac_10b_0.vss row_dac_10b_0.vdd 0.78467f
C3 latch_sense_p_ext sar_comparator_input 0.09095f
C4 row_drive sar_readout_12b_0.vdd 0.58157f
C5 m4_45060_36440# sar_comparator_input 0.05954f
C6 vdd_ext eval 0
C7 shared_converter_mux_0.vdd vss 0.2816f
C8 m1_68300_3080# sar_comparator_input 0.05195f
C9 vdd_ext shared_converter_mux_0.mux_bus 0.00217f
C10 row_drive vss 0.22445f
C11 vss latch_sense_n_ext 0.29037f
C12 reset decision_n 0.31048f
C13 sar_readout_12b_0.vss sar_readout_12b_0.vdd 0.49712f
C14 reset tail_ext 0.17577f
C15 m4_45060_36440# latch_sense_p_ext 0.00631f
C16 decision_p latch_sense_p_ext 0.37635f
C17 vss sar_comparator_input 0.05708f
C18 decision_n latch_sense_n_ext 0.37635f
C19 vdd_ext iso_tail_ext 0.86179f
C20 tail_ext latch_sense_n_ext 1.09601f
C21 vdd_ext preamp_iso_tail_ext 0.01046f
C22 shared_converter_mux_0.vdd shared_converter_mux_0.mux_bus 1.55306f
C23 vdd_ext reset 4.48789f
C24 row_drive shared_converter_mux_0.mux_bus 0.06281f
C25 m4_32000_38940# latch_sense_n_ext 0.0096f
C26 decision_n sar_comparator_input 0.17131f
C27 shared_converter_mux_0.vdd vdd_ext 0
C28 vdd_ext row_drive 5.04788f
C29 vss latch_sense_p_ext 0.29037f
C30 vdd_ext latch_sense_n_ext 4.55721f
C31 row_drive m2_42000_41940# 0.12051f
C32 row_drive iso_tail_ext 2.39704f
C33 iso_tail_ext latch_sense_n_ext 0.12999f
C34 vdd_ext sar_comparator_input 1.73531f
C35 vdd_ext sar_readout_12b_0.vss 0.93663f
C36 tail_ext latch_sense_p_ext 0.99589f
C37 row_drive preamp_iso_tail_ext 0.08458f
C38 latch_sense_n_ext preamp_iso_tail_ext 0.36983f
C39 decision_n decision_p 2.54301f
C40 eval latch_sense_p_ext 0.19752f
C41 tail_ext decision_p 0.48065f
C42 shared_converter_mux_0.vdd row_drive 0.00246f
C43 iso_tail_ext sar_comparator_input 0.16721f
C44 row_drive vdd 0.1964f
C45 sar_readout_12b_0.vss iso_tail_ext 0.60045f
C46 m4_32000_38940# latch_sense_p_ext 0.00354f
C47 row_drive latch_sense_n_ext 0.81732f
C48 preamp_iso_tail_ext sar_comparator_input 0.10537f
C49 vdd_ext latch_sense_p_ext 5.38432f
C50 shared_converter_mux_0.mux_bus shared_converter_mux_0.vss 1.56188f
C51 vdd_ext m4_45060_36440# 0.01404f
C52 vdd_ext decision_p 3.8282f
C53 vdd_ext shared_converter_mux_0.vss 0
C54 row_dac_10b_0.vss row_drive 1.08123f
C55 vdd_ext m1_68300_3080# 0.24419f
C56 row_drive sar_comparator_input 5.48055f
C57 sar_readout_12b_0.vss row_drive 0.29433f
C58 latch_sense_n_ext sar_comparator_input 0.68401f
C59 iso_tail_ext latch_sense_p_ext 0.1295f
C60 vdd_ext sar_readout_12b_0.vdd 1.39936f
C61 latch_sense_p_ext preamp_iso_tail_ext 0.28327f
C62 shared_converter_mux_0.mux_bus vss 0.03132f
C63 reset latch_sense_p_ext 0.19529f
C64 decision_n tail_ext 0.48065f
C65 reset decision_p 0.376f
C66 vdd_ext vss 0.19458f
C67 iso_tail_ext sar_readout_12b_0.vdd 0.27521f
C68 row_dac_10b_0.vdd row_drive 1.11462f
C69 row_drive latch_sense_p_ext 1.32666f
C70 latch_sense_n_ext latch_sense_p_ext 0.59927f
C71 eval tail_ext 0.36751f
C72 row_drive m4_45060_36440# 0.09499f
C73 row_drive shared_converter_mux_0.vss 0.00246f
C74 row_drive m1_68300_3080# 2.68328f
C75 vss vss_escape 36.2394f
C76 vdd vss_escape 36.7f
C77 iso_tail_ext vss_escape 75.97121f
C78 decision_p vss_escape 13.13722f
C79 tail_ext vss_escape 0.13154p
C80 latch_sense_p_ext vss_escape 55.003f
C81 preamp_iso_tail_ext vss_escape 23.44093f
C82 vdd_ext vss_escape 0.26363p
C83 m4_45060_36440# vss_escape 0.08796f ; **FLOATING
C84 m4_32000_38940# vss_escape 0.1568f ; **FLOATING
C85 m2_42000_41940# vss_escape 3.91591f ; **FLOATING
C86 sar_readout_12b_0.vss vss_escape 1.33686f ; **FLOATING
C87 row_dac_10b_0.vss vss_escape 1.40333f ; **FLOATING
C88 row_dac_10b_0.vdd vss_escape 1.33457f ; **FLOATING
C89 sar_readout_12b_0.vdd vss_escape 1.77614f ; **FLOATING
C90 m1_68300_3080# vss_escape 7.89552f ; **FLOATING
C91 shared_converter_mux_0.vss vss_escape 1.39454f ; **FLOATING
C92 shared_converter_mux_0.mux_bus vss_escape 2.86922f ; **FLOATING
C93 shared_converter_mux_0.vdd vss_escape 0.95985f ; **FLOATING
.ends
