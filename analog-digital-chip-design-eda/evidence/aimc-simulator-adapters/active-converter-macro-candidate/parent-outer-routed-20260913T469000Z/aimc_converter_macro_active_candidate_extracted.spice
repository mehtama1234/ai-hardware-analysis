* NGSPICE file created from aimc_converter_macro_active_candidate_flat.ext - technology: sky130A

.subckt aimc_converter_macro_active_candidate_flat vss vdd row_drive sar_comparator_input
+ decision_p decision_n reset eval vss_escape latch_sense_p_ext iso_tail_ext tail_ext
+ vdd_ext
X0 physical_preamp_n.drain physical_preamp_n.gate latch_sense_p_ext vss_escape sky130_fd_pr__nfet_01v8 ad=3.36 pd=8 as=3.12 ps=7.6 w=1.2 l=0.6
X1 vdd_ext decision_p decision_n vdd_ext sky130_fd_pr__pfet_01v8 ad=3.12 pd=7.6 as=3.36 ps=8 w=1.2 l=0.6
X2 tail_ext eval vss_escape vss_escape sky130_fd_pr__nfet_01v8 ad=16.2 pd=17.4 as=16.2 ps=17.4 w=6 l=0.6
X3 decision_p latch_sense_p_ext tail_ext vss_escape sky130_fd_pr__nfet_01v8 ad=3.36 pd=8 as=3.12 ps=7.6 w=1.2 l=0.6
X4 vdd_ext reset decision_n vdd_ext sky130_fd_pr__pfet_01v8 ad=3.12 pd=7.6 as=3.36 ps=8 w=1.2 l=0.6
X5 tail_ext latch_sense_p_ext decision_n vss_escape sky130_fd_pr__nfet_01v8 ad=3.12 pd=7.6 as=3.36 ps=8 w=1.2 l=0.6
X6 decision_p decision_n vdd_ext vdd_ext sky130_fd_pr__pfet_01v8 ad=3.36 pd=8 as=3.12 ps=7.6 w=1.2 l=0.6
X7 tail_ext decision_p decision_n vss_escape sky130_fd_pr__nfet_01v8 ad=3.12 pd=7.6 as=3.36 ps=8 w=1.2 l=0.6
X8 latch_sense_p_ext row_drive iso_tail_ext vss_escape sky130_fd_pr__nfet_01v8 ad=3.36 pd=8 as=3.12 ps=7.6 w=1.2 l=0.6
X9 iso_tail_ext sar_comparator_input latch_sense_p_ext vss_escape sky130_fd_pr__nfet_01v8 ad=3.12 pd=7.6 as=3.36 ps=8 w=1.2 l=0.6
X10 latch_sense_p_ext row_drive latch_sense_p_ext vss_escape sky130_fd_pr__nfet_01v8 ad=3.12 pd=7.6 as=16.32 ps=39.2 w=1.2 l=0.6
X11 decision_p reset vdd_ext vdd_ext sky130_fd_pr__pfet_01v8 ad=3.36 pd=8 as=3.12 ps=7.6 w=1.2 l=0.6
X12 decision_p decision_n tail_ext vss_escape sky130_fd_pr__nfet_01v8 ad=3.36 pd=8 as=3.12 ps=7.6 w=1.2 l=0.6
C0 physical_preamp_n.drain latch_sense_p_ext 0.09874f
C1 row_drive sar_readout_12b_0.vss 0.29433f
C2 m4_45060_36440# latch_sense_p_ext 0.05596f
C3 row_drive vss 0.22445f
C4 physical_preamp_n.gate physical_preamp_n.drain 0.08798f
C5 vdd_ext latch_sense_p_ext 9.76201f
C6 decision_n tail_ext 0.48065f
C7 physical_preamp_n.gate vdd_ext 0.01545f
C8 row_drive sar_comparator_input 5.22878f
C9 row_drive m1_68300_3080# 2.68328f
C10 decision_p tail_ext 0.48065f
C11 vss latch_sense_p_ext 0.58074f
C12 eval latch_sense_p_ext 0.19752f
C13 vdd_ext sar_readout_12b_0.vdd 1.39936f
C14 vdd_ext tail_ext 1.9856f
C15 sar_comparator_input latch_sense_p_ext 0.04367f
C16 vdd_ext m4_51060_36440# 0.01404f
C17 vdd_ext iso_tail_ext 0.86179f
C18 vdd_ext shared_converter_mux_0.vdd 0
C19 vdd_ext shared_converter_mux_0.mux_bus 0.00217f
C20 sar_readout_12b_0.vdd sar_readout_12b_0.vss 0.49712f
C21 row_dac_10b_0.vdd row_drive 1.11462f
C22 row_drive latch_sense_p_ext 2.05011f
C23 row_dac_10b_0.vss row_drive 1.08123f
C24 reset latch_sense_p_ext 0.19529f
C25 physical_preamp_n.gate row_drive 0.12269f
C26 sar_readout_12b_0.vss iso_tail_ext 0.60045f
C27 vdd_ext shared_converter_mux_0.vss 0
C28 tail_ext eval 0.36751f
C29 vss shared_converter_mux_0.vdd 0.2816f
C30 vss shared_converter_mux_0.mux_bus 0.03132f
C31 sar_comparator_input iso_tail_ext 0.16721f
C32 row_dac_10b_0.vss row_dac_10b_0.vdd 0.78467f
C33 physical_preamp_n.gate latch_sense_p_ext 0.60612f
C34 sar_readout_12b_0.vdd row_drive 0.58157f
C35 reset tail_ext 0.17577f
C36 decision_p decision_n 2.54301f
C37 row_drive iso_tail_ext 2.39704f
C38 row_drive shared_converter_mux_0.vdd 0.00246f
C39 row_drive shared_converter_mux_0.mux_bus 0.06281f
C40 vdd_ext decision_n 3.9382f
C41 tail_ext latch_sense_p_ext 2.0919f
C42 row_drive shared_converter_mux_0.vss 0.00246f
C43 m4_51060_36440# latch_sense_p_ext 0.00179f
C44 vdd_ext decision_p 3.8282f
C45 physical_preamp_n.gate m4_51060_36440# 0.13059f
C46 iso_tail_ext latch_sense_p_ext 0.25949f
C47 vdd_ext physical_preamp_n.drain 0.01216f
C48 vdd_ext m4_45060_36440# 0.01404f
C49 sar_readout_12b_0.vdd iso_tail_ext 0.27521f
C50 vdd_ext sar_readout_12b_0.vss 0.93663f
C51 row_drive vdd 0.1964f
C52 vdd_ext vss 0.19458f
C53 decision_n reset 0.31048f
C54 decision_p reset 0.376f
C55 vdd_ext eval 0
C56 shared_converter_mux_0.vdd shared_converter_mux_0.mux_bus 1.55306f
C57 vdd_ext sar_comparator_input 1.06679f
C58 vdd_ext m1_68300_3080# 0.24419f
C59 row_drive m4_45060_36440# 0.12238f
C60 decision_n latch_sense_p_ext 0.37635f
C61 vdd_ext row_drive 3.84053f
C62 shared_converter_mux_0.mux_bus shared_converter_mux_0.vss 1.56188f
C63 vdd_ext reset 4.48789f
C64 decision_p latch_sense_p_ext 0.37635f
C65 vss vss_escape 36.2394f
C66 vdd vss_escape 36.7f
C67 iso_tail_ext vss_escape 77.06784f
C68 decision_p vss_escape 15.8656f
C69 tail_ext vss_escape 0.13823p
C70 latch_sense_p_ext vss_escape 56.09965f
C71 vdd_ext vss_escape 0.25263p
C72 m4_51060_36440# vss_escape 0.13014f ; **FLOATING
C73 m4_45060_36440# vss_escape 0.09656f ; **FLOATING
C74 sar_readout_12b_0.vss vss_escape 1.33686f ; **FLOATING
C75 row_dac_10b_0.vss vss_escape 1.40333f ; **FLOATING
C76 row_dac_10b_0.vdd vss_escape 1.33457f ; **FLOATING
C77 sar_readout_12b_0.vdd vss_escape 1.77614f ; **FLOATING
C78 m1_68300_3080# vss_escape 7.89552f ; **FLOATING
C79 shared_converter_mux_0.vss vss_escape 1.39454f ; **FLOATING
C80 shared_converter_mux_0.mux_bus vss_escape 2.86922f ; **FLOATING
C81 shared_converter_mux_0.vdd vss_escape 0.95985f ; **FLOATING
C82 physical_preamp_n.drain vss_escape 4.71732f
.ends
