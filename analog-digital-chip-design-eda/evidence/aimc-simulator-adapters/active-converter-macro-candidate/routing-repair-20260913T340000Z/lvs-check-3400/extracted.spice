* NGSPICE file created from aimc_converter_macro_active_candidate_flat.ext - technology: sky130A

.subckt aimc_converter_macro_active_candidate_flat vss vdd row_drive sar_comparator_input
+ decision_p decision_n reset eval vss_escape latch_sense_p_ext latch_sense_n_ext
+ iso_tail_ext tail_ext vdd_ext
X0 physical_preamp_0.preamp_iso_tail_ext sar_comparator_input physical_preamp_0.latch_sense_n_ext vss_escape sky130_fd_pr__nfet_01v8 ad=3.12 pd=7.6 as=3.36 ps=8 w=1.2 l=0.6
X1 vdd_ext decision_p decision_n vdd_ext sky130_fd_pr__pfet_01v8 ad=3.12 pd=7.6 as=3.36 ps=8 w=1.2 l=0.6
X2 tail_ext eval vss_escape vss_escape sky130_fd_pr__nfet_01v8 ad=16.2 pd=17.4 as=16.2 ps=17.4 w=6 l=0.6
X3 physical_preamp_0.latch_sense_p_ext row_drive physical_preamp_0.preamp_iso_tail_ext vss_escape sky130_fd_pr__nfet_01v8 ad=3.36 pd=8 as=3.12 ps=7.6 w=1.2 l=0.6
X4 decision_p latch_sense_p_ext tail_ext vss_escape sky130_fd_pr__nfet_01v8 ad=3.36 pd=8 as=3.12 ps=7.6 w=1.2 l=0.6
X5 vdd_ext reset decision_n vdd_ext sky130_fd_pr__pfet_01v8 ad=3.12 pd=7.6 as=3.36 ps=8 w=1.2 l=0.6
X6 tail_ext latch_sense_n_ext decision_n vss_escape sky130_fd_pr__nfet_01v8 ad=3.12 pd=7.6 as=3.36 ps=8 w=1.2 l=0.6
X7 decision_p decision_n vdd_ext vdd_ext sky130_fd_pr__pfet_01v8 ad=3.36 pd=8 as=3.12 ps=7.6 w=1.2 l=0.6
X8 tail_ext decision_p decision_n vss_escape sky130_fd_pr__nfet_01v8 ad=3.12 pd=7.6 as=3.36 ps=8 w=1.2 l=0.6
X9 latch_sense_p_ext row_drive iso_tail_ext vss_escape sky130_fd_pr__nfet_01v8 ad=3.36 pd=8 as=3.12 ps=7.6 w=1.2 l=0.6
X10 iso_tail_ext sar_comparator_input latch_sense_n_ext vss_escape sky130_fd_pr__nfet_01v8 ad=3.12 pd=7.6 as=3.36 ps=8 w=1.2 l=0.6
X11 decision_p reset vdd_ext vdd_ext sky130_fd_pr__pfet_01v8 ad=3.36 pd=8 as=3.12 ps=7.6 w=1.2 l=0.6
X12 decision_p decision_n tail_ext vss_escape sky130_fd_pr__nfet_01v8 ad=3.36 pd=8 as=3.12 ps=7.6 w=1.2 l=0.6
C0 vdd_ext latch_sense_p_ext 3.43095f
C1 latch_sense_n_ext decision_n 0.18428f
C2 physical_preamp_0.preamp_iso_tail_ext m1_68300_3080# 0.01748f
C3 shared_converter_mux_0.vss vdd_ext 0
C4 physical_preamp_0.preamp_iso_tail_ext m2_64900_1400# 0.34398f
C5 decision_p vdd_ext 3.8282f
C6 physical_preamp_0.preamp_iso_tail_ext physical_preamp_0.latch_sense_n_ext 0.05717f
C7 shared_converter_mux_0.mux_bus shared_converter_mux_0.vdd 1.55306f
C8 vdd_ext row_drive 3.85718f
C9 reset tail_ext 0.17577f
C10 iso_tail_ext latch_sense_p_ext 0.12577f
C11 shared_converter_mux_0.vdd vss 0.2816f
C12 m1_68300_3080# m2_64900_1400# 0
C13 shared_converter_mux_0.mux_bus vss 0.03132f
C14 vss latch_sense_n_ext 0.23329f
C15 sar_readout_12b_0.vdd vdd_ext 1.39936f
C16 vdd_ext decision_n 3.9382f
C17 m1_68300_3080# physical_preamp_0.latch_sense_n_ext 0
C18 physical_preamp_0.preamp_iso_tail_ext vdd_ext 0.18336f
C19 iso_tail_ext row_drive 2.39704f
C20 m2_64900_1400# physical_preamp_0.latch_sense_n_ext 0.41846f
C21 eval vdd_ext 0
C22 tail_ext latch_sense_p_ext 0.0334f
C23 sar_comparator_input row_drive 5.29847f
C24 shared_converter_mux_0.vdd vdd_ext 0
C25 physical_preamp_0.latch_sense_p_ext row_drive 0.02765f
C26 sar_readout_12b_0.vss row_drive 0.29433f
C27 sar_readout_12b_0.vdd iso_tail_ext 0.27521f
C28 tail_ext decision_p 0.48065f
C29 shared_converter_mux_0.mux_bus vdd_ext 0.00217f
C30 reset decision_p 0.376f
C31 m1_68300_3080# vdd_ext 0.24419f
C32 vdd_ext latch_sense_n_ext 3.48444f
C33 m2_64900_1400# vdd_ext 0.06307f
C34 vdd_ext vss 0.19458f
C35 physical_preamp_0.preamp_iso_tail_ext sar_comparator_input 0.14938f
C36 physical_preamp_0.latch_sense_n_ext vdd_ext 0.00673f
C37 sar_readout_12b_0.vdd sar_readout_12b_0.vss 0.49712f
C38 row_dac_10b_0.vss row_drive 1.08123f
C39 physical_preamp_0.preamp_iso_tail_ext physical_preamp_0.latch_sense_p_ext 0.05749f
C40 tail_ext decision_n 0.48065f
C41 reset decision_n 0.31048f
C42 iso_tail_ext latch_sense_n_ext 0.12577f
C43 decision_p latch_sense_p_ext 0.18428f
C44 tail_ext eval 0.36751f
C45 row_drive latch_sense_p_ext 0.6214f
C46 vdd row_drive 0.1964f
C47 m1_68300_3080# sar_comparator_input 0
C48 sar_comparator_input latch_sense_n_ext 0.04279f
C49 shared_converter_mux_0.vss row_drive 0.00246f
C50 m2_64900_1400# sar_comparator_input 0.21578f
C51 row_dac_10b_0.vdd row_dac_10b_0.vss 0.78467f
C52 m1_68300_3080# physical_preamp_0.latch_sense_p_ext 0
C53 physical_preamp_0.latch_sense_n_ext sar_comparator_input 0.05007f
C54 m2_64900_1400# physical_preamp_0.latch_sense_p_ext 0.41846f
C55 tail_ext latch_sense_n_ext 0.0334f
C56 physical_preamp_0.latch_sense_p_ext physical_preamp_0.latch_sense_n_ext 0.00782f
C57 vdd_ext iso_tail_ext 0.86179f
C58 decision_p decision_n 2.54301f
C59 sar_readout_12b_0.vdd row_drive 0.58157f
C60 row_dac_10b_0.vdd row_drive 1.11462f
C61 sar_comparator_input vdd_ext 1.05969f
C62 physical_preamp_0.preamp_iso_tail_ext row_drive 0.35661f
C63 physical_preamp_0.latch_sense_p_ext vdd_ext 0.01996f
C64 sar_readout_12b_0.vss vdd_ext 0.93663f
C65 shared_converter_mux_0.mux_bus shared_converter_mux_0.vss 1.56188f
C66 vss latch_sense_p_ext 0.23329f
C67 shared_converter_mux_0.vdd row_drive 0.00246f
C68 tail_ext vdd_ext 1.9856f
C69 reset vdd_ext 4.48789f
C70 shared_converter_mux_0.mux_bus row_drive 0.06281f
C71 m1_68300_3080# row_drive 2.68356f
C72 row_drive latch_sense_n_ext 0.57746f
C73 sar_comparator_input iso_tail_ext 0.16721f
C74 m2_64900_1400# row_drive 0.05066f
C75 vss row_drive 0.22445f
C76 sar_readout_12b_0.vss iso_tail_ext 0.60045f
C77 physical_preamp_0.latch_sense_n_ext row_drive 0.00475f
C78 physical_preamp_0.latch_sense_p_ext sar_comparator_input 0.02717f
C79 vss vss_escape 36.2292f
C80 vdd vss_escape 36.7f
C81 iso_tail_ext vss_escape 20.9682f
C82 decision_p vss_escape 7.38983f
C83 tail_ext vss_escape 81.08725f
C84 vdd_ext vss_escape 0.2571p
C85 m2_64900_1400# vss_escape 0.72762f ; **FLOATING
C86 sar_readout_12b_0.vss vss_escape 1.33686f ; **FLOATING
C87 row_dac_10b_0.vss vss_escape 1.40333f ; **FLOATING
C88 row_dac_10b_0.vdd vss_escape 1.33457f ; **FLOATING
C89 sar_readout_12b_0.vdd vss_escape 1.77614f ; **FLOATING
C90 m1_68300_3080# vss_escape 7.90194f ; **FLOATING
C91 shared_converter_mux_0.vss vss_escape 1.39454f ; **FLOATING
C92 shared_converter_mux_0.mux_bus vss_escape 2.86922f ; **FLOATING
C93 shared_converter_mux_0.vdd vss_escape 0.95985f ; **FLOATING
C94 physical_preamp_0.latch_sense_n_ext vss_escape 10.07028f
C95 physical_preamp_0.latch_sense_p_ext vss_escape 37.16722f
C96 physical_preamp_0.preamp_iso_tail_ext vss_escape 49.36008f
.ends
