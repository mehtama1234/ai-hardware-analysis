* NGSPICE file created from aimc_converter_macro_active_candidate.ext - technology: sky130A

.subckt escaped_input_latch out_p out_n latch_sense_p latch_sense_n tail reset vdd
+ vss eval sense_p sense_n iso_tail vdd_active
X0 out_p out_n vdd_active vdd_active sky130_fd_pr__pfet_01v8 ad=6.72 pd=10.4 as=6.24 ps=10 w=2.4 l=0.6
X1 vdd reset out_n vdd sky130_fd_pr__pfet_01v8 ad=3.12 pd=7.6 as=3.36 ps=8 w=1.2 l=0.6
X2 tail out_p out_n vss sky130_fd_pr__nfet_01v8 ad=12.48 pd=14.8 as=13.44 ps=15.2 w=4.8 l=0.6
X3 out_p reset vdd vdd sky130_fd_pr__pfet_01v8 ad=3.36 pd=8 as=3.12 ps=7.6 w=1.2 l=0.6
X4 out_p out_n tail vss sky130_fd_pr__nfet_01v8 ad=13.44 pd=15.2 as=12.48 ps=14.8 w=4.8 l=0.6
X5 tail latch_sense_n out_n vss sky130_fd_pr__nfet_01v8 ad=12.48 pd=14.8 as=13.44 ps=15.2 w=4.8 l=0.6
X6 tail eval vss vss sky130_fd_pr__nfet_01v8 ad=16.2 pd=17.4 as=16.2 ps=17.4 w=6 l=0.6
X7 out_p latch_sense_p tail vss sky130_fd_pr__nfet_01v8 ad=13.44 pd=15.2 as=12.48 ps=14.8 w=4.8 l=0.6
X8 iso_tail sense_n latch_sense_n vss sky130_fd_pr__nfet_01v8 ad=3.12 pd=7.6 as=3.36 ps=8 w=1.2 l=0.6
X9 vdd_active out_p out_n vdd_active sky130_fd_pr__pfet_01v8 ad=6.24 pd=10 as=6.72 ps=10.4 w=2.4 l=0.6
X10 latch_sense_p sense_p iso_tail vss sky130_fd_pr__nfet_01v8 ad=3.36 pd=8 as=3.12 ps=7.6 w=1.2 l=0.6
C0 iso_tail sense_n 0.10725f
C1 out_p tail 0.51868f
C2 vdd out_n 0.76206f
C3 iso_tail sense_p 0.10725f
C4 latch_sense_p tail 0.0334f
C5 latch_sense_n out_n 0.1874f
C6 eval tail 0.09547f
C7 iso_tail latch_sense_n 0.07366f
C8 out_p latch_sense_p 0.1874f
C9 sense_n latch_sense_n 0.02861f
C10 reset out_p 0.31048f
C11 vdd_active out_n 2.87636f
C12 tail out_n 0.51868f
C13 out_p out_n 2.60132f
C14 vdd tail 0.94872f
C15 iso_tail latch_sense_p 0.07366f
C16 tail latch_sense_n 0.0334f
C17 reset out_n 0.31048f
C18 vdd out_p 0.76206f
C19 vdd_active tail 0.94872f
C20 latch_sense_p sense_p 0.02861f
C21 reset vdd 4.03064f
C22 vdd_active out_p 2.82313f
C23 iso_tail vss 25.79857f
C24 latch_sense_n vss 1.99533f
C25 latch_sense_p vss 1.99533f
C26 out_n vss 10.04998f
C27 tail vss 75.84002f
C28 vdd_active vss 83.71092f
C29 vdd vss 72.40037f
.ends

.subckt aimc_converter_macro_active_candidate vss vdd row_drive sar_comparator_input
+ decision_p decision_n reset eval vdd_active
Xconverter_latch_0 decision_p decision_n converter_latch_0/latch_sense_p converter_latch_0/latch_sense_n
+ converter_latch_0/tail converter_latch_0/reset converter_latch_0/vdd VSUBS converter_latch_0/eval
+ row_drive sar_comparator_input converter_latch_0/iso_tail converter_latch_0/vdd
+ escaped_input_latch
C0 converter_latch_0/vdd sar_readout_12b_0/vdd 1.39936f
C1 converter_latch_0/iso_tail row_drive 0.26293f
C2 row_drive vdd 0.1964f
C3 vss shared_converter_mux_0/mux_bus 0.03132f
C4 row_drive shared_converter_mux_0/mux_bus 0.06281f
C5 converter_latch_0/tail decision_n 0.01085f
C6 row_drive row_dac_10b_0/vss 1.08123f
C7 sar_readout_12b_0/vss row_drive 0.21493f
C8 converter_latch_0/vdd shared_converter_mux_0/vss 0
C9 decision_p converter_latch_0/vdd 0
C10 vss converter_latch_0/latch_sense_p 0.23329f
C11 vss shared_converter_mux_0/vdd 0.2816f
C12 converter_latch_0/vdd vss 0.19458f
C13 row_drive shared_converter_mux_0/vdd 0.00246f
C14 converter_latch_0/vdd row_drive 1.55835f
C15 sar_readout_12b_0/vss converter_latch_0/iso_tail 0.60149f
C16 converter_latch_0/tail decision_p 0.01085f
C17 row_drive sar_readout_12b_0/vdd 0.33461f
C18 sar_comparator_input converter_latch_0/iso_tail 0.08712f
C19 converter_latch_0/iso_tail converter_latch_0/vdd 0.31557f
C20 row_dac_10b_0/vdd row_drive 1.11409f
C21 converter_latch_0/iso_tail sar_readout_12b_0/vdd 0.27625f
C22 shared_converter_mux_0/mux_bus shared_converter_mux_0/vdd 1.55306f
C23 converter_latch_0/vdd shared_converter_mux_0/mux_bus 0.00217f
C24 row_drive shared_converter_mux_0/vss 0.00246f
C25 sar_readout_12b_0/vss converter_latch_0/vdd 0.93663f
C26 row_drive vss 0.22445f
C27 sar_readout_12b_0/vss sar_readout_12b_0/vdd 0.49712f
C28 converter_latch_0/vdd shared_converter_mux_0/vdd 0
C29 row_dac_10b_0/vdd row_dac_10b_0/vss 0.78467f
C30 converter_latch_0/latch_sense_n vss 0.23329f
C31 shared_converter_mux_0/mux_bus shared_converter_mux_0/vss 1.56188f
C32 vss VSUBS 30.5941f
C33 vdd VSUBS 30.5941f
C34 sar_comparator_input VSUBS 0.93057f
C35 decision_n VSUBS 3.8093f
C36 row_drive VSUBS 6.8802f
C37 converter_latch_0/vdd VSUBS 37.3374f
.ends
