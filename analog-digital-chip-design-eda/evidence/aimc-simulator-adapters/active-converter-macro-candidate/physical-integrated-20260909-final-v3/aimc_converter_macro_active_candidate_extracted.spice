* NGSPICE file created from aimc_converter_macro_active_candidate_flat.ext - technology: sky130A

.subckt aimc_converter_macro_active_candidate_flat vss vdd row_drive sar_comparator_input
+ decision_p decision_n reset eval vss_escape latch_sense_p_ext latch_sense_n_ext
+ iso_tail_ext tail_ext vdd_ext
X0 vdd_ext physical_preamp_0.sense_n vdd_ext vss_escape sky130_fd_pr__nfet_01v8 ad=3.36 pd=8 as=15.36 ps=44 w=1.2 l=0.6
X1 vdd_ext decision_p decision_n vdd_ext sky130_fd_pr__pfet_01v8 ad=3.12 pd=7.6 as=3.36 ps=8 w=1.2 l=0.6
X2 tail_ext eval vss_escape vss_escape sky130_fd_pr__nfet_01v8 ad=16.2 pd=17.4 as=16.2 ps=17.4 w=6 l=0.6
X3 vdd_ext physical_preamp_0.sense_p vdd_ext vss_escape sky130_fd_pr__nfet_01v8 ad=3.12 pd=7.6 as=0 ps=0 w=1.2 l=0.6
X4 decision_p latch_sense_p_ext tail_ext vss_escape sky130_fd_pr__nfet_01v8 ad=3.36 pd=8 as=3.12 ps=7.6 w=1.2 l=0.6
X5 vdd_ext reset decision_n vdd_ext sky130_fd_pr__pfet_01v8 ad=3.12 pd=7.6 as=3.36 ps=8 w=1.2 l=0.6
X6 tail_ext latch_sense_n_ext decision_n vss_escape sky130_fd_pr__nfet_01v8 ad=3.12 pd=7.6 as=3.36 ps=8 w=1.2 l=0.6
X7 decision_p decision_n vdd_ext vdd_ext sky130_fd_pr__pfet_01v8 ad=3.36 pd=8 as=3.12 ps=7.6 w=1.2 l=0.6
X8 tail_ext decision_p decision_n vss_escape sky130_fd_pr__nfet_01v8 ad=3.12 pd=7.6 as=3.36 ps=8 w=1.2 l=0.6
X9 latch_sense_p_ext row_drive iso_tail_ext vss_escape sky130_fd_pr__nfet_01v8 ad=3.36 pd=8 as=3.12 ps=7.6 w=1.2 l=0.6
X10 iso_tail_ext sar_comparator_input latch_sense_n_ext vss_escape sky130_fd_pr__nfet_01v8 ad=3.12 pd=7.6 as=3.36 ps=8 w=1.2 l=0.6
X11 decision_p reset vdd_ext vdd_ext sky130_fd_pr__pfet_01v8 ad=3.36 pd=8 as=3.12 ps=7.6 w=1.2 l=0.6
X12 decision_p decision_n tail_ext vss_escape sky130_fd_pr__nfet_01v8 ad=3.36 pd=8 as=3.12 ps=7.6 w=1.2 l=0.6
C0 vdd_ext iso_tail_ext 0.86179f
C1 vdd_ext m1_68000_3740# 0.01112f
C2 reset decision_p 0.376f
C3 reset vdd_ext 4.48789f
C4 vdd_ext latch_sense_n_ext 3.48444f
C5 iso_tail_ext latch_sense_p_ext 0.12577f
C6 vss row_drive 0.22445f
C7 sar_readout_12b_0.vdd vdd_ext 1.39936f
C8 vdd_ext decision_p 3.8282f
C9 row_drive sar_comparator_input 5.23145f
C10 physical_preamp_0.sense_p vdd_ext 0.19576f
C11 physical_preamp_0.sense_n sar_comparator_input 0.07548f
C12 sar_readout_12b_0.vss row_drive 0.29422f
C13 vss m4_69940_3740# 0.00152f
C14 latch_sense_p_ext decision_p 0.18428f
C15 shared_converter_mux_0.mux_bus vdd_ext 0.00217f
C16 vdd_ext latch_sense_p_ext 3.43095f
C17 shared_converter_mux_0.vss vdd_ext 0
C18 physical_preamp_0.sense_p m2_64900_1400# 0.03637f
C19 vdd_ext m2_64900_1400# 1.28748f
C20 row_dac_10b_0.vss row_drive 1.08123f
C21 vdd_ext shared_converter_mux_0.vdd 0
C22 tail_ext eval 0.36751f
C23 shared_converter_mux_0.mux_bus shared_converter_mux_0.vss 1.56188f
C24 m1_68000_3740# vss 0.005f
C25 iso_tail_ext sar_comparator_input 0.16721f
C26 iso_tail_ext row_drive 1.97962f
C27 shared_converter_mux_0.mux_bus shared_converter_mux_0.vdd 1.55306f
C28 vss latch_sense_n_ext 0.23329f
C29 sar_comparator_input latch_sense_n_ext 0.04279f
C30 sar_readout_12b_0.vss iso_tail_ext 0.60045f
C31 tail_ext decision_n 0.48065f
C32 row_drive latch_sense_n_ext 0.20099f
C33 tail_ext reset 0.17577f
C34 physical_preamp_0.sense_p sar_comparator_input 0.04049f
C35 tail_ext latch_sense_n_ext 0.0334f
C36 vdd_ext vss 0.20794f
C37 sar_readout_12b_0.vdd row_drive 0.57218f
C38 vdd_ext sar_comparator_input 1.15045f
C39 row_dac_10b_0.vdd row_drive 1.11462f
C40 physical_preamp_0.sense_p row_drive 0.08156f
C41 vdd_ext row_drive 2.72292f
C42 sar_readout_12b_0.vdd sar_readout_12b_0.vss 0.49712f
C43 vdd_ext physical_preamp_0.sense_n 0.15628f
C44 shared_converter_mux_0.mux_bus vss 0.03132f
C45 vdd_ext sar_readout_12b_0.vss 0.93663f
C46 vss latch_sense_p_ext 0.23329f
C47 tail_ext decision_p 0.48065f
C48 reset decision_n 0.31048f
C49 eval vdd_ext 0
C50 latch_sense_n_ext decision_n 0.18428f
C51 m2_64900_1400# sar_comparator_input 0.1759f
C52 tail_ext vdd_ext 1.9856f
C53 shared_converter_mux_0.mux_bus row_drive 0.06281f
C54 iso_tail_ext latch_sense_n_ext 0.12577f
C55 shared_converter_mux_0.vss row_drive 0.00246f
C56 row_drive latch_sense_p_ext 0.24412f
C57 m1_70000_6000# vss 0.00242f
C58 shared_converter_mux_0.vdd vss 0.2816f
C59 m2_64900_1400# row_drive 0.00382f
C60 row_dac_10b_0.vdd row_dac_10b_0.vss 0.78467f
C61 row_drive vdd 0.1964f
C62 m2_64900_1400# physical_preamp_0.sense_n 0.03955f
C63 shared_converter_mux_0.vdd row_drive 0.00246f
C64 decision_n decision_p 2.54301f
C65 tail_ext latch_sense_p_ext 0.0334f
C66 sar_readout_12b_0.vdd iso_tail_ext 0.27521f
C67 vdd_ext decision_n 3.9382f
C68 vss vss_escape 36.2176f
C69 vdd vss_escape 36.7f
C70 iso_tail_ext vss_escape 55.47765f
C71 latch_sense_n_ext vss_escape 8.9128f
C72 latch_sense_p_ext vss_escape 24.51655f
C73 decision_p vss_escape 7.45999f
C74 tail_ext vss_escape 81.67176f
C75 vdd_ext vss_escape 0.26699p
C76 m4_69940_3740# vss_escape 0.08998f ; **FLOATING
C77 m2_64900_1400# vss_escape 0.69994f ; **FLOATING
C78 sar_readout_12b_0.vss vss_escape 1.33686f ; **FLOATING
C79 row_dac_10b_0.vss vss_escape 1.40333f ; **FLOATING
C80 row_dac_10b_0.vdd vss_escape 1.33457f ; **FLOATING
C81 sar_readout_12b_0.vdd vss_escape 1.77614f ; **FLOATING
C82 shared_converter_mux_0.vss vss_escape 1.39454f ; **FLOATING
C83 m1_68000_3740# vss_escape 0.35067f ; **FLOATING
C84 shared_converter_mux_0.mux_bus vss_escape 2.86922f ; **FLOATING
C85 shared_converter_mux_0.vdd vss_escape 0.95985f ; **FLOATING
C86 m1_70000_6000# vss_escape 0.10112f ; **FLOATING
.ends
