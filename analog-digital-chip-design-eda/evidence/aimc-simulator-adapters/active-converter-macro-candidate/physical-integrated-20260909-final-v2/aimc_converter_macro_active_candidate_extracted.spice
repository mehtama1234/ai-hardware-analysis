* NGSPICE file created from aimc_converter_macro_active_candidate_flat.ext - technology: sky130A

.subckt aimc_converter_macro_active_candidate_flat vss vdd row_drive sar_comparator_input
+ decision_p decision_n reset eval vss_escape latch_sense_p_ext latch_sense_n_ext
+ iso_tail_ext tail_ext vdd_ext
X0 vdd_ext physical_preamp_0.sense_n vdd_ext vss_escape sky130_fd_pr__nfet_01v8 ad=3.36 pd=8 as=15.36 ps=44 w=1.2 l=0.6
X1 vdd_ext decision_p decision_n vdd_ext sky130_fd_pr__pfet_01v8 ad=3.12 pd=7.6 as=3.36 ps=8 w=1.2 l=0.6
X2 tail_ext eval vss_escape vss_escape sky130_fd_pr__nfet_01v8 ad=16.2 pd=17.4 as=16.2 ps=17.4 w=6 l=0.6
X3 vdd_ext physical_preamp_0.sense_p vdd_ext vss_escape sky130_fd_pr__nfet_01v8 ad=3.12 pd=7.6 as=0 ps=0 w=1.2 l=0.6
X4 decision_p latch_sense_p_ext tail_ext vss_escape sky130_fd_pr__nfet_01v8 ad=3.36 pd=8 as=3.12 ps=7.6 w=1.2 l=0.6
X5 vdd_ext reset decision_n vdd_ext sky130_fd_pr__pfet_01v8 ad=3.12 pd=7.6 as=3.36 ps=8 w=1.2 l=0.6
X6 tail_ext latch_sense_n_ext decision_n vss_escape sky130_fd_pr__nfet_01v8 ad=3.12 pd=7.6 as=3.36 ps=8 w=1.2 l=0.6
X7 decision_p decision_n vdd_ext vdd_ext sky130_fd_pr__pfet_01v8 ad=3.36 pd=8 as=3.12 ps=7.6 w=1.2 l=0.6
X8 tail_ext decision_p decision_n vss_escape sky130_fd_pr__nfet_01v8 ad=3.12 pd=7.6 as=3.36 ps=8 w=1.2 l=0.6
X9 latch_sense_p_ext row_drive iso_tail_ext vss_escape sky130_fd_pr__nfet_01v8 ad=3.36 pd=8 as=3.12 ps=7.6 w=1.2 l=0.6
X10 iso_tail_ext sar_comparator_input latch_sense_n_ext vss_escape sky130_fd_pr__nfet_01v8 ad=3.12 pd=7.6 as=3.36 ps=8 w=1.2 l=0.6
X11 decision_p reset vdd_ext vdd_ext sky130_fd_pr__pfet_01v8 ad=3.36 pd=8 as=3.12 ps=7.6 w=1.2 l=0.6
X12 decision_p decision_n tail_ext vss_escape sky130_fd_pr__nfet_01v8 ad=3.36 pd=8 as=3.12 ps=7.6 w=1.2 l=0.6
C0 row_dac_10b_0.vss row_drive 1.08123f
C1 row_dac_10b_0.vss row_dac_10b_0.vdd 0.78467f
C2 row_drive latch_sense_p_ext 0.24412f
C3 sar_readout_12b_0.vss row_drive 0.29422f
C4 physical_preamp_0.sense_p row_drive 0.08156f
C5 iso_tail_ext vdd_ext 0.86179f
C6 physical_preamp_0.sense_n vdd_ext 0.15628f
C7 decision_p reset 0.376f
C8 reset vdd_ext 4.48789f
C9 shared_converter_mux_0.vss row_drive 0.00246f
C10 decision_p vdd_ext 3.8282f
C11 m2_64900_1400# physical_preamp_0.sense_n 0.03955f
C12 row_dac_10b_0.vdd row_drive 1.11462f
C13 iso_tail_ext latch_sense_n_ext 0.12577f
C14 sar_readout_12b_0.vdd iso_tail_ext 0.27521f
C15 shared_converter_mux_0.vdd row_drive 0.00246f
C16 shared_converter_mux_0.vss shared_converter_mux_0.mux_bus 1.56188f
C17 m2_64900_1400# vdd_ext 1.28748f
C18 shared_converter_mux_0.mux_bus row_drive 0.06281f
C19 m4_69940_3740# vss 0.00152f
C20 tail_ext eval 0.36751f
C21 iso_tail_ext sar_comparator_input 0.16721f
C22 shared_converter_mux_0.vdd shared_converter_mux_0.mux_bus 1.55306f
C23 vdd_ext latch_sense_n_ext 3.48444f
C24 vss vdd_ext 0.20794f
C25 physical_preamp_0.sense_n sar_comparator_input 0.07548f
C26 sar_readout_12b_0.vdd vdd_ext 1.39936f
C27 reset decision_n 0.31048f
C28 decision_p decision_n 2.54301f
C29 decision_n vdd_ext 3.9382f
C30 iso_tail_ext latch_sense_p_ext 0.12577f
C31 vdd_ext sar_comparator_input 1.15045f
C32 sar_readout_12b_0.vss iso_tail_ext 0.60045f
C33 vss latch_sense_n_ext 0.23329f
C34 m2_64900_1400# sar_comparator_input 0.1759f
C35 decision_p latch_sense_p_ext 0.18428f
C36 vdd row_drive 0.1964f
C37 vdd_ext latch_sense_p_ext 3.43095f
C38 decision_n latch_sense_n_ext 0.18428f
C39 sar_readout_12b_0.vss vdd_ext 0.93663f
C40 reset tail_ext 0.17577f
C41 sar_comparator_input latch_sense_n_ext 0.04279f
C42 physical_preamp_0.sense_p vdd_ext 0.19576f
C43 decision_p tail_ext 0.48065f
C44 iso_tail_ext row_drive 1.97962f
C45 tail_ext vdd_ext 1.9856f
C46 physical_preamp_0.sense_p m2_64900_1400# 0.03637f
C47 m1_68000_3740# vdd_ext 0.01112f
C48 shared_converter_mux_0.vss vdd_ext 0
C49 vss latch_sense_p_ext 0.23329f
C50 vdd_ext row_drive 2.72292f
C51 sar_readout_12b_0.vss sar_readout_12b_0.vdd 0.49712f
C52 tail_ext latch_sense_n_ext 0.0334f
C53 m2_64900_1400# row_drive 0.00382f
C54 shared_converter_mux_0.vdd vdd_ext 0
C55 shared_converter_mux_0.mux_bus vdd_ext 0.00217f
C56 physical_preamp_0.sense_p sar_comparator_input 0.04049f
C57 m1_68000_3740# vss 0.005f
C58 decision_n tail_ext 0.48065f
C59 row_drive latch_sense_n_ext 0.20099f
C60 vss row_drive 0.22445f
C61 sar_readout_12b_0.vdd row_drive 0.57218f
C62 shared_converter_mux_0.vdd vss 0.2816f
C63 vdd_ext eval 0
C64 shared_converter_mux_0.mux_bus vss 0.03132f
C65 sar_comparator_input row_drive 5.23145f
C66 tail_ext latch_sense_p_ext 0.0334f
C67 vss vss_escape 36.2232f
C68 vdd vss_escape 36.7f
C69 iso_tail_ext vss_escape 55.47765f
C70 latch_sense_n_ext vss_escape 8.9128f
C71 latch_sense_p_ext vss_escape 24.51655f
C72 decision_p vss_escape 7.45999f
C73 tail_ext vss_escape 81.67176f
C74 vdd_ext vss_escape 0.26699p
C75 m4_69940_3740# vss_escape 0.08998f ; **FLOATING
C76 m2_64900_1400# vss_escape 0.69994f ; **FLOATING
C77 sar_readout_12b_0.vss vss_escape 1.33686f ; **FLOATING
C78 row_dac_10b_0.vss vss_escape 1.40333f ; **FLOATING
C79 row_dac_10b_0.vdd vss_escape 1.33457f ; **FLOATING
C80 sar_readout_12b_0.vdd vss_escape 1.77614f ; **FLOATING
C81 shared_converter_mux_0.vss vss_escape 1.39454f ; **FLOATING
C82 m1_68000_3740# vss_escape 0.35067f ; **FLOATING
C83 shared_converter_mux_0.mux_bus vss_escape 2.86922f ; **FLOATING
C84 shared_converter_mux_0.vdd vss_escape 0.95985f ; **FLOATING
.ends
