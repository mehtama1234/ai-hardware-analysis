* NGSPICE file created from aimc_converter_macro_active_candidate_flat.ext - technology: sky130A

.subckt aimc_converter_macro_active_candidate_flat vss vdd row_drive decision_p decision_n
+ reset eval vss_escape latch_sense_p_ext latch_sense_n_ext iso_tail_ext tail_ext
+ vdd_ext preamp_iso_tail_ext
X0 physical_preamp_0.iso_tail physical_preamp_0.sense_n physical_preamp_0.iso_n vss_escape sky130_fd_pr__nfet_01v8 ad=3.12 pd=7.6 as=3.36 ps=8 w=1.2 l=0.6
X1 vdd_ext decision_p decision_n vdd_ext sky130_fd_pr__pfet_01v8 ad=3.12 pd=7.6 as=3.36 ps=8 w=1.2 l=0.6
X2 tail_ext eval vss_escape vss_escape sky130_fd_pr__nfet_01v8 ad=16.2 pd=17.4 as=16.2 ps=17.4 w=6 l=0.6
X3 physical_preamp_0.iso_p physical_preamp_0.sense_p physical_preamp_0.iso_tail vss_escape sky130_fd_pr__nfet_01v8 ad=3.36 pd=8 as=3.12 ps=7.6 w=1.2 l=0.6
X4 decision_p latch_sense_p_ext tail_ext vss_escape sky130_fd_pr__nfet_01v8 ad=3.36 pd=8 as=3.12 ps=7.6 w=1.2 l=0.6
X5 vdd_ext reset decision_n vdd_ext sky130_fd_pr__pfet_01v8 ad=3.12 pd=7.6 as=3.36 ps=8 w=1.2 l=0.6
X6 tail_ext latch_sense_n_ext decision_n vss_escape sky130_fd_pr__nfet_01v8 ad=3.12 pd=7.6 as=3.36 ps=8 w=1.2 l=0.6
X7 decision_p decision_n vdd_ext vdd_ext sky130_fd_pr__pfet_01v8 ad=3.36 pd=8 as=3.12 ps=7.6 w=1.2 l=0.6
X8 tail_ext decision_p decision_n vss_escape sky130_fd_pr__nfet_01v8 ad=3.12 pd=7.6 as=3.36 ps=8 w=1.2 l=0.6
X9 latch_sense_p_ext row_drive iso_tail_ext vss_escape sky130_fd_pr__nfet_01v8 ad=3.36 pd=8 as=3.12 ps=7.6 w=1.2 l=0.6
X10 iso_tail_ext row_drive latch_sense_n_ext vss_escape sky130_fd_pr__nfet_01v8 ad=3.12 pd=7.6 as=3.36 ps=8 w=1.2 l=0.6
X11 decision_p reset vdd_ext vdd_ext sky130_fd_pr__pfet_01v8 ad=3.36 pd=8 as=3.12 ps=7.6 w=1.2 l=0.6
X12 decision_p decision_n tail_ext vss_escape sky130_fd_pr__nfet_01v8 ad=3.36 pd=8 as=3.12 ps=7.6 w=1.2 l=0.6
C0 physical_preamp_0.sense_n row_drive 0.01945f
C1 latch_sense_p_ext row_drive 0.24412f
C2 physical_preamp_0.sense_p row_drive 0.11476f
C3 latch_sense_p_ext decision_p 0.18428f
C4 latch_sense_n_ext tail_ext 0.0334f
C5 row_drive vdd 0.1964f
C6 sar_readout_12b_0.vss iso_tail_ext 0.60045f
C7 shared_converter_mux_0.vdd vss 0.2816f
C8 vss vdd_ext 0.20794f
C9 shared_converter_mux_0.mux_bus vss 0.03132f
C10 decision_n reset 0.31048f
C11 physical_preamp_0.sense_n physical_preamp_0.iso_tail 0.11179f
C12 preamp_iso_tail_ext m1_69940_2940# 0.03103f
C13 decision_p reset 0.376f
C14 physical_preamp_0.iso_p physical_preamp_0.iso_n 0.00782f
C15 m2_64900_1400# physical_preamp_0.sense_n 0.04273f
C16 physical_preamp_0.sense_p physical_preamp_0.iso_tail 0.12292f
C17 shared_converter_mux_0.vdd row_drive 0.00246f
C18 row_drive vdd_ext 3.74813f
C19 shared_converter_mux_0.mux_bus row_drive 0.06281f
C20 physical_preamp_0.sense_p m2_64900_1400# 0.0393f
C21 decision_n vdd_ext 3.9382f
C22 row_dac_10b_0.vss row_drive 1.08123f
C23 iso_tail_ext latch_sense_p_ext 0.12577f
C24 decision_p vdd_ext 3.8282f
C25 vss latch_sense_n_ext 0.23329f
C26 physical_preamp_0.iso_tail vdd_ext 0.30577f
C27 physical_preamp_0.iso_n m1_67440_500# 0.0015f
C28 sar_readout_12b_0.vss vdd_ext 0.93663f
C29 m2_64900_1400# vdd_ext 0.07266f
C30 decision_n tail_ext 0.48065f
C31 sar_readout_12b_0.vdd row_drive 0.57218f
C32 row_drive latch_sense_n_ext 0.24379f
C33 decision_p tail_ext 0.48065f
C34 decision_n latch_sense_n_ext 0.18428f
C35 row_dac_10b_0.vss row_dac_10b_0.vdd 0.78467f
C36 physical_preamp_0.iso_p row_drive 0.01833f
C37 physical_preamp_0.iso_n row_drive 0.01683f
C38 shared_converter_mux_0.vss vdd_ext 0
C39 shared_converter_mux_0.mux_bus shared_converter_mux_0.vss 1.56188f
C40 iso_tail_ext vdd_ext 0.86179f
C41 eval vdd_ext 0
C42 physical_preamp_0.sense_n vdd_ext 0.0039f
C43 physical_preamp_0.iso_tail physical_preamp_0.iso_p 0.05749f
C44 sar_readout_12b_0.vss sar_readout_12b_0.vdd 0.49712f
C45 latch_sense_p_ext vdd_ext 3.43095f
C46 physical_preamp_0.iso_tail physical_preamp_0.iso_n 0.05717f
C47 row_drive m1_67440_500# 0.07672f
C48 vss row_drive 0.22445f
C49 physical_preamp_0.sense_p vdd_ext 0.03215f
C50 m2_64900_1400# physical_preamp_0.iso_p 0.41846f
C51 m2_64900_1400# physical_preamp_0.iso_n 0.41846f
C52 reset vdd_ext 4.48789f
C53 sar_readout_12b_0.vdd iso_tail_ext 0.27521f
C54 iso_tail_ext latch_sense_n_ext 0.12577f
C55 tail_ext eval 0.36751f
C56 physical_preamp_0.iso_tail m1_67440_500# 0.0015f
C57 latch_sense_p_ext tail_ext 0.0334f
C58 shared_converter_mux_0.vdd vdd_ext 0
C59 m2_64900_1400# m1_67440_500# 0.01113f
C60 shared_converter_mux_0.mux_bus shared_converter_mux_0.vdd 1.55306f
C61 shared_converter_mux_0.mux_bus vdd_ext 0.00217f
C62 physical_preamp_0.sense_n physical_preamp_0.iso_n 0.02157f
C63 reset tail_ext 0.17577f
C64 decision_p decision_n 2.54301f
C65 physical_preamp_0.iso_tail row_drive 0.06718f
C66 physical_preamp_0.sense_p physical_preamp_0.iso_p 0.02157f
C67 sar_readout_12b_0.vss row_drive 0.29422f
C68 m2_64900_1400# row_drive 0.05108f
C69 row_drive row_dac_10b_0.vdd 1.11462f
C70 tail_ext vdd_ext 1.9856f
C71 physical_preamp_0.sense_n m1_67440_500# 0.04555f
C72 vss latch_sense_p_ext 0.23329f
C73 sar_readout_12b_0.vdd vdd_ext 1.39936f
C74 latch_sense_n_ext vdd_ext 3.48444f
C75 shared_converter_mux_0.vss row_drive 0.00246f
C76 physical_preamp_0.iso_p vdd_ext 0.02484f
C77 iso_tail_ext row_drive 2.14683f
C78 physical_preamp_0.iso_n vdd_ext 0.0106f
C79 m2_64900_1400# physical_preamp_0.iso_tail 0.34398f
C80 preamp_iso_tail_ext vss_escape 0.18641f
C81 vss vss_escape 36.2292f
C82 vdd vss_escape 36.7f
C83 iso_tail_ext vss_escape 55.49465f
C84 latch_sense_p_ext vss_escape 33.44635f
C85 decision_p vss_escape 7.45999f
C86 tail_ext vss_escape 81.67176f
C87 vdd_ext vss_escape 0.25962p
C88 m2_64900_1400# vss_escape 0.99808f ; **FLOATING
C89 sar_readout_12b_0.vss vss_escape 1.33686f ; **FLOATING
C90 row_dac_10b_0.vss vss_escape 1.40333f ; **FLOATING
C91 m1_67440_500# vss_escape 0.31893f ; **FLOATING
C92 row_dac_10b_0.vdd vss_escape 1.33457f ; **FLOATING
C93 sar_readout_12b_0.vdd vss_escape 1.77614f ; **FLOATING
C94 m1_69940_2940# vss_escape 0.19727f ; **FLOATING
C95 shared_converter_mux_0.vss vss_escape 1.39454f ; **FLOATING
C96 shared_converter_mux_0.mux_bus vss_escape 2.86922f ; **FLOATING
C97 shared_converter_mux_0.vdd vss_escape 0.95985f ; **FLOATING
C98 physical_preamp_0.iso_n vss_escape 1.04634f
C99 physical_preamp_0.iso_p vss_escape 1.04634f
C100 physical_preamp_0.iso_tail vss_escape 4.2324f
.ends
