* NGSPICE file created from aimc_converter_macro_active_candidate_flat.ext - technology: sky130A

.subckt aimc_converter_macro_active_candidate_flat vss vdd row_drive sar_comparator_input
+ decision_p decision_n reset eval vss_escape latch_sense_p_ext latch_sense_n_ext
+ iso_tail_ext tail_ext vdd_ext
X0 physical_preamp_0.preamp_iso_tail_ext sar_comparator_input physical_preamp_0.latch_sense_n_ext vss_escape sky130_fd_pr__nfet_01v8 ad=3.12 pd=7.6 as=3.36 ps=8 w=1.2 l=0.6
X1 vdd_ext decision_p decision_n vdd_ext sky130_fd_pr__pfet_01v8 ad=3.12 pd=7.6 as=3.36 ps=8 w=1.2 l=0.6
X2 tail_ext eval vss_escape vss_escape sky130_fd_pr__nfet_01v8 ad=16.2 pd=17.4 as=16.2 ps=17.4 w=6 l=0.6
X3 physical_preamp_0.latch_sense_p_ext row_drive physical_preamp_0.preamp_iso_tail_ext vss_escape sky130_fd_pr__nfet_01v8 ad=3.36 pd=8 as=3.12 ps=7.6 w=1.2 l=0.6
X4 decision_p latch_sense_p_ext tail_ext vss_escape sky130_fd_pr__nfet_01v8 ad=3.36 pd=8 as=3.12 ps=7.6 w=1.2 l=0.6
X5 vdd_ext reset decision_n vdd_ext sky130_fd_pr__pfet_01v8 ad=3.12 pd=7.6 as=3.36 ps=8 w=1.2 l=0.6
X6 tail_ext latch_sense_n_ext decision_n vss_escape sky130_fd_pr__nfet_01v8 ad=3.12 pd=7.6 as=3.36 ps=8 w=1.2 l=0.6
X7 decision_p decision_n vdd_ext vdd_ext sky130_fd_pr__pfet_01v8 ad=3.36 pd=8 as=3.12 ps=7.6 w=1.2 l=0.6
X8 tail_ext decision_p decision_n vss_escape sky130_fd_pr__nfet_01v8 ad=3.12 pd=7.6 as=3.36 ps=8 w=1.2 l=0.6
X9 latch_sense_p_ext row_drive iso_tail_ext vss_escape sky130_fd_pr__nfet_01v8 ad=3.36 pd=8 as=3.12 ps=7.6 w=1.2 l=0.6
X10 iso_tail_ext sar_comparator_input latch_sense_n_ext vss_escape sky130_fd_pr__nfet_01v8 ad=3.12 pd=7.6 as=3.36 ps=8 w=1.2 l=0.6
X11 decision_p reset vdd_ext vdd_ext sky130_fd_pr__pfet_01v8 ad=3.36 pd=8 as=3.12 ps=7.6 w=1.2 l=0.6
X12 decision_p decision_n tail_ext vss_escape sky130_fd_pr__nfet_01v8 ad=3.36 pd=8 as=3.12 ps=7.6 w=1.2 l=0.6
C0 vdd_ext sar_comparator_input 0.06859f
C1 vdd_ext shared_converter_mux_0.mux_bus 0.00217f
C2 m1_68300_3080# row_drive 3.72253f
C3 vdd_ext tail_ext 1.9856f
C4 m1_65180_1400# row_drive 0.71321f
C5 eval tail_ext 0.36751f
C6 physical_preamp_0.preamp_iso_tail_ext row_drive 0.41874f
C7 vss sar_comparator_input 0.05708f
C8 shared_converter_mux_0.mux_bus vss 0.03132f
C9 physical_preamp_0.latch_sense_n_ext m2_64900_1400# 0.48274f
C10 m1_68300_3080# physical_preamp_0.latch_sense_p_ext 0
C11 m1_65180_1400# physical_preamp_0.latch_sense_p_ext 0.06921f
C12 physical_preamp_0.preamp_iso_tail_ext physical_preamp_0.latch_sense_p_ext 0.03291f
C13 vss latch_sense_p_ext 0.23483f
C14 vdd_ext m1_68300_3080# 0.15428f
C15 vdd_ext reset 4.48789f
C16 shared_converter_mux_0.vdd row_drive 0.00246f
C17 shared_converter_mux_0.vss row_drive 0.00246f
C18 tail_ext decision_p 0.48065f
C19 latch_sense_p_ext decision_p 0.18428f
C20 row_dac_10b_0.vss row_drive 1.08123f
C21 latch_sense_n_ext decision_n 0.18428f
C22 row_drive iso_tail_ext 2.39704f
C23 physical_preamp_0.latch_sense_n_ext row_drive 0.18101f
C24 latch_sense_n_ext iso_tail_ext 0.21209f
C25 m1_65180_1400# vss 0.00102f
C26 tail_ext latch_sense_p_ext 0.0334f
C27 row_dac_10b_0.vss row_dac_10b_0.vdd 0.78467f
C28 shared_converter_mux_0.vdd vdd_ext 0
C29 vdd_ext decision_n 3.9382f
C30 vdd_ext shared_converter_mux_0.vss 0
C31 decision_p reset 0.376f
C32 m1_68300_3080# sar_comparator_input 0.07262f
C33 physical_preamp_0.latch_sense_p_ext physical_preamp_0.latch_sense_n_ext 0.00824f
C34 m1_65180_1400# sar_comparator_input 0.00413f
C35 vdd_ext iso_tail_ext 0.3078f
C36 physical_preamp_0.preamp_iso_tail_ext sar_comparator_input 0.21886f
C37 sar_readout_12b_0.vss iso_tail_ext 0.60045f
C38 m2_64900_1400# row_drive 0.0739f
C39 tail_ext reset 0.17577f
C40 shared_converter_mux_0.vdd vss 0.2816f
C41 sar_readout_12b_0.vdd iso_tail_ext 0.27521f
C42 decision_n decision_p 2.54301f
C43 vss physical_preamp_0.latch_sense_n_ext 0.00437f
C44 physical_preamp_0.latch_sense_p_ext m2_64900_1400# 0.4047f
C45 shared_converter_mux_0.vdd shared_converter_mux_0.mux_bus 1.55306f
C46 shared_converter_mux_0.vss shared_converter_mux_0.mux_bus 1.56188f
C47 vdd row_drive 0.1964f
C48 sar_comparator_input iso_tail_ext 0.16721f
C49 m1_65180_1400# m1_68300_3080# 0.12858f
C50 physical_preamp_0.preamp_iso_tail_ext m1_68300_3080# 0.01748f
C51 physical_preamp_0.latch_sense_n_ext sar_comparator_input 0.16338f
C52 tail_ext decision_n 0.48065f
C53 physical_preamp_0.preamp_iso_tail_ext m1_65180_1400# 0.14439f
C54 latch_sense_n_ext row_drive 1.06835f
C55 iso_tail_ext latch_sense_p_ext 0.21294f
C56 physical_preamp_0.latch_sense_p_ext row_drive 0.03151f
C57 row_dac_10b_0.vdd row_drive 1.11462f
C58 vdd_ext row_drive 2.91195f
C59 decision_n reset 0.31048f
C60 sar_readout_12b_0.vss row_drive 0.29433f
C61 sar_comparator_input m2_64900_1400# 0.25407f
C62 m1_68300_3080# physical_preamp_0.latch_sense_n_ext 0.13081f
C63 sar_readout_12b_0.vdd row_drive 0.58157f
C64 m1_65180_1400# physical_preamp_0.latch_sense_n_ext 0
C65 vss row_drive 1.35968f
C66 physical_preamp_0.preamp_iso_tail_ext physical_preamp_0.latch_sense_n_ext 0.14951f
C67 eval vdd_ext 0
C68 vss latch_sense_n_ext 0.23985f
C69 vdd_ext sar_readout_12b_0.vss 0.93663f
C70 sar_comparator_input row_drive 5.42913f
C71 shared_converter_mux_0.mux_bus row_drive 0.06281f
C72 vdd_ext sar_readout_12b_0.vdd 1.39936f
C73 sar_comparator_input latch_sense_n_ext 0.23009f
C74 m1_68300_3080# m2_64900_1400# 0
C75 vdd_ext vss 0.19458f
C76 m1_65180_1400# m2_64900_1400# 0.13847f
C77 sar_readout_12b_0.vdd sar_readout_12b_0.vss 0.49712f
C78 physical_preamp_0.preamp_iso_tail_ext m2_64900_1400# 0.33864f
C79 row_drive latch_sense_p_ext 1.13418f
C80 physical_preamp_0.latch_sense_p_ext sar_comparator_input 0.02717f
C81 vdd_ext decision_p 3.8282f
C82 tail_ext latch_sense_n_ext 0.0334f
C83 vss vss_escape 36.2292f
C84 vdd vss_escape 36.7f
C85 iso_tail_ext vss_escape 20.9682f
C86 decision_p vss_escape 7.71981f
C87 tail_ext vss_escape 83.89029f
C88 vdd_ext vss_escape 0.23925p
C89 m2_64900_1400# vss_escape 0.6881f ; **FLOATING
C90 sar_readout_12b_0.vss vss_escape 1.33686f ; **FLOATING
C91 row_dac_10b_0.vss vss_escape 1.40333f ; **FLOATING
C92 row_dac_10b_0.vdd vss_escape 1.33457f ; **FLOATING
C93 sar_readout_12b_0.vdd vss_escape 1.77614f ; **FLOATING
C94 m1_65180_1400# vss_escape 0.93143f ; **FLOATING
C95 m1_68300_3080# vss_escape 7.90194f ; **FLOATING
C96 shared_converter_mux_0.vss vss_escape 1.39454f ; **FLOATING
C97 shared_converter_mux_0.mux_bus vss_escape 2.86922f ; **FLOATING
C98 shared_converter_mux_0.vdd vss_escape 0.95985f ; **FLOATING
C99 physical_preamp_0.latch_sense_n_ext vss_escape 25.62962f
C100 physical_preamp_0.latch_sense_p_ext vss_escape 70.98233f
C101 physical_preamp_0.preamp_iso_tail_ext vss_escape 97.35442f
.ends
