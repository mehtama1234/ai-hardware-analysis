* NGSPICE file created from aimc_converter_macro_active_candidate_flat.ext - technology: sky130A

.subckt aimc_converter_macro_active_candidate_flat vss vdd row_drive sar_comparator_input
+ decision_p decision_n reset eval vss_escape latch_sense_n_ext iso_tail_ext tail_ext
+ vdd_ext
X0 vdd_ext decision_p decision_n vdd_ext sky130_fd_pr__pfet_01v8 ad=3.12 pd=7.6 as=3.36 ps=8 w=1.2 l=0.6
X1 tail_ext eval vss_escape vss_escape sky130_fd_pr__nfet_01v8 ad=16.2 pd=17.4 as=16.2 ps=17.4 w=6 l=0.6
X2 latch_sense_n_ext sar_comparator_input row_drive vss_escape sky130_fd_pr__nfet_01v8 ad=3.36 pd=8 as=3.12 ps=7.6 w=1.2 l=0.6
X3 decision_p row_drive tail_ext vss_escape sky130_fd_pr__nfet_01v8 ad=3.36 pd=8 as=3.12 ps=7.6 w=1.2 l=0.6
X4 vdd_ext reset decision_n vdd_ext sky130_fd_pr__pfet_01v8 ad=3.12 pd=7.6 as=3.36 ps=8 w=1.2 l=0.6
X5 tail_ext latch_sense_n_ext decision_n vss_escape sky130_fd_pr__nfet_01v8 ad=3.12 pd=7.6 as=3.36 ps=8 w=1.2 l=0.6
X6 decision_p decision_n vdd_ext vdd_ext sky130_fd_pr__pfet_01v8 ad=3.36 pd=8 as=3.12 ps=7.6 w=1.2 l=0.6
X7 tail_ext decision_p decision_n vss_escape sky130_fd_pr__nfet_01v8 ad=3.12 pd=7.6 as=3.36 ps=8 w=1.2 l=0.6
X8 row_drive row_drive iso_tail_ext vss_escape sky130_fd_pr__nfet_01v8 ad=3.36 pd=8 as=3.12 ps=7.6 w=1.2 l=0.6
X9 iso_tail_ext sar_comparator_input latch_sense_n_ext vss_escape sky130_fd_pr__nfet_01v8 ad=3.12 pd=7.6 as=3.36 ps=8 w=1.2 l=0.6
X10 decision_p reset vdd_ext vdd_ext sky130_fd_pr__pfet_01v8 ad=3.36 pd=8 as=3.12 ps=7.6 w=1.2 l=0.6
X11 row_drive row_drive row_drive vss_escape sky130_fd_pr__nfet_01v8 ad=3.12 pd=7.6 as=12.96 ps=31.2 w=1.2 l=0.6
X12 decision_p decision_n tail_ext vss_escape sky130_fd_pr__nfet_01v8 ad=3.36 pd=8 as=3.12 ps=7.6 w=1.2 l=0.6
C0 iso_tail_ext sar_readout_12b_0.vdd 0.27521f
C1 vdd_ext reset 4.48789f
C2 m1_68300_3080# row_drive 2.68328f
C3 sar_readout_12b_0.vdd row_drive 0.58157f
C4 decision_n reset 0.31048f
C5 shared_converter_mux_0.vdd vss 0.2816f
C6 vss sar_comparator_input 0.09437f
C7 shared_converter_mux_0.vdd shared_converter_mux_0.mux_bus 1.55306f
C8 row_dac_10b_0.vdd row_drive 1.11462f
C9 vdd_ext sar_readout_12b_0.vss 0.93663f
C10 iso_tail_ext latch_sense_n_ext 0.12577f
C11 tail_ext eval 0.36751f
C12 row_drive latch_sense_n_ext 0.9394f
C13 vdd_ext vss 0.19458f
C14 sar_readout_12b_0.vss sar_readout_12b_0.vdd 0.49712f
C15 tail_ext sar_comparator_input 0.21605f
C16 vdd_ext shared_converter_mux_0.mux_bus 0.00217f
C17 eval vdd_ext 0
C18 tail_ext vdd_ext 1.9856f
C19 row_dac_10b_0.vss row_drive 1.08123f
C20 shared_converter_mux_0.vdd vdd_ext 0
C21 tail_ext decision_n 0.48065f
C22 vdd_ext sar_comparator_input 1.59762f
C23 sar_comparator_input decision_n 0.27273f
C24 vss latch_sense_n_ext 0.23329f
C25 shared_converter_mux_0.vss row_drive 0.00246f
C26 decision_p row_drive 0.31086f
C27 sar_comparator_input m1_68300_3080# 0.05195f
C28 iso_tail_ext row_drive 2.52281f
C29 vdd row_drive 0.1964f
C30 decision_p reset 0.376f
C31 vdd_ext decision_n 3.9382f
C32 vdd_ext m1_68300_3080# 0.24419f
C33 tail_ext latch_sense_n_ext 0.0334f
C34 vdd_ext sar_readout_12b_0.vdd 1.39936f
C35 sar_comparator_input latch_sense_n_ext 0.46897f
C36 iso_tail_ext sar_readout_12b_0.vss 0.60045f
C37 sar_readout_12b_0.vss row_drive 0.29433f
C38 shared_converter_mux_0.mux_bus shared_converter_mux_0.vss 1.56188f
C39 vdd_ext latch_sense_n_ext 3.50535f
C40 vss row_drive 0.73376f
C41 decision_n latch_sense_n_ext 0.18428f
C42 shared_converter_mux_0.mux_bus row_drive 0.06281f
C43 tail_ext decision_p 0.48065f
C44 tail_ext row_drive 0.07814f
C45 iso_tail_ext sar_comparator_input 0.16721f
C46 shared_converter_mux_0.vdd row_drive 0.00246f
C47 sar_comparator_input row_drive 6.96126f
C48 tail_ext reset 0.17577f
C49 vdd_ext shared_converter_mux_0.vss 0
C50 vdd_ext decision_p 3.8282f
C51 decision_n decision_p 2.54301f
C52 iso_tail_ext vdd_ext 0.86179f
C53 vss shared_converter_mux_0.mux_bus 0.03132f
C54 row_dac_10b_0.vss row_dac_10b_0.vdd 0.78467f
C55 vdd_ext row_drive 7.67978f
C56 vss vss_escape 36.2045f
C57 vdd vss_escape 36.7f
C58 iso_tail_ext vss_escape 20.9682f
C59 decision_p vss_escape 21.45989f
C60 tail_ext vss_escape 0.18355p
C61 vdd_ext vss_escape 0.26106p
C62 sar_readout_12b_0.vss vss_escape 1.33686f ; **FLOATING
C63 row_dac_10b_0.vss vss_escape 1.40333f ; **FLOATING
C64 row_dac_10b_0.vdd vss_escape 1.33457f ; **FLOATING
C65 sar_readout_12b_0.vdd vss_escape 1.77614f ; **FLOATING
C66 m1_68300_3080# vss_escape 7.89552f ; **FLOATING
C67 shared_converter_mux_0.vss vss_escape 1.39454f ; **FLOATING
C68 shared_converter_mux_0.mux_bus vss_escape 2.86922f ; **FLOATING
C69 shared_converter_mux_0.vdd vss_escape 0.95985f ; **FLOATING
.ends
