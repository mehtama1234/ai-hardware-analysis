* NGSPICE file created from aimc_converter_macro_active_candidate_flat.ext - technology: sky130A

.subckt aimc_converter_macro_active_candidate_flat vss vdd row_drive sar_comparator_input
+ decision_p decision_n reset eval vss_escape latch_sense_p_ext iso_tail_ext tail_ext
+ vdd_ext latch_sense_n_ext_uq1
X0 latch_sense_n_ext physical_preamp_n.sar_comparator_input latch_sense_n_ext_uq1 vss_escape sky130_fd_pr__nfet_01v8 ad=3.36 pd=8 as=3.12 ps=7.6 w=1.2 l=0.6
X1 vdd_ext decision_p decision_n vdd_ext sky130_fd_pr__pfet_01v8 ad=3.12 pd=7.6 as=3.36 ps=8 w=1.2 l=0.6
X2 tail_ext eval vss_escape vss_escape sky130_fd_pr__nfet_01v8 ad=16.2 pd=17.4 as=16.2 ps=17.4 w=6 l=0.6
X3 decision_p latch_sense_p_ext tail_ext vss_escape sky130_fd_pr__nfet_01v8 ad=3.36 pd=8 as=3.12 ps=7.6 w=1.2 l=0.6
X4 vdd_ext reset decision_n vdd_ext sky130_fd_pr__pfet_01v8 ad=3.12 pd=7.6 as=3.36 ps=8 w=1.2 l=0.6
X5 tail_ext latch_sense_n_ext_uq1 decision_n vss_escape sky130_fd_pr__nfet_01v8 ad=3.12 pd=7.6 as=3.36 ps=8 w=1.2 l=0.6
X6 decision_p decision_n vdd_ext vdd_ext sky130_fd_pr__pfet_01v8 ad=3.36 pd=8 as=3.12 ps=7.6 w=1.2 l=0.6
X7 tail_ext decision_p decision_n vss_escape sky130_fd_pr__nfet_01v8 ad=3.12 pd=7.6 as=3.36 ps=8 w=1.2 l=0.6
X8 latch_sense_p_ext row_drive iso_tail_ext vss_escape sky130_fd_pr__nfet_01v8 ad=3.36 pd=8 as=3.12 ps=7.6 w=1.2 l=0.6
X9 iso_tail_ext sar_comparator_input latch_sense_n_ext_uq1 vss_escape sky130_fd_pr__nfet_01v8 ad=3.12 pd=7.6 as=3.36 ps=8 w=1.2 l=0.6
X10 physical_preamp_p.latch_sense_p_ext row_drive latch_sense_n_ext_uq1 vss_escape sky130_fd_pr__nfet_01v8 ad=3.36 pd=8 as=3.12 ps=7.6 w=1.2 l=0.6
X11 decision_p reset vdd_ext vdd_ext sky130_fd_pr__pfet_01v8 ad=3.36 pd=8 as=3.12 ps=7.6 w=1.2 l=0.6
X12 decision_p decision_n tail_ext vss_escape sky130_fd_pr__nfet_01v8 ad=3.36 pd=8 as=3.12 ps=7.6 w=1.2 l=0.6
C0 sar_comparator_input vdd_ext 1.06679f
C1 latch_sense_n_ext_uq1 vdd_ext 4.71191f
C2 decision_n decision_p 2.54301f
C3 tail_ext decision_p 0.48065f
C4 physical_preamp_p.latch_sense_p_ext row_drive 0.08419f
C5 row_dac_10b_0.vdd row_drive 1.11462f
C6 sar_comparator_input latch_sense_n_ext_uq1 0.04367f
C7 row_dac_10b_0.vss row_dac_10b_0.vdd 0.78467f
C8 shared_converter_mux_0.vss vdd_ext 0
C9 m1_68300_3080# vdd_ext 0.24419f
C10 physical_preamp_n.sar_comparator_input vdd_ext 0.01545f
C11 sar_readout_12b_0.vss row_drive 0.29433f
C12 m4_51060_36440# vdd_ext 0.01404f
C13 vss latch_sense_p_ext 0.29037f
C14 sar_readout_12b_0.vdd row_drive 0.58157f
C15 latch_sense_p_ext row_drive 0.70701f
C16 physical_preamp_n.sar_comparator_input latch_sense_n_ext_uq1 0.40781f
C17 vss vdd_ext 0.19458f
C18 m4_51060_36440# latch_sense_n_ext_uq1 0.00822f
C19 latch_sense_p_ext decision_p 0.37635f
C20 row_drive vdd_ext 3.84053f
C21 vdd row_drive 0.1964f
C22 decision_p vdd_ext 3.8282f
C23 decision_n tail_ext 0.48065f
C24 reset decision_p 0.376f
C25 latch_sense_n_ext vdd_ext 0.01216f
C26 vss latch_sense_n_ext_uq1 0.29037f
C27 shared_converter_mux_0.vdd vdd_ext 0
C28 sar_comparator_input row_drive 5.22878f
C29 iso_tail_ext sar_readout_12b_0.vss 0.60045f
C30 latch_sense_n_ext_uq1 row_drive 1.18654f
C31 eval tail_ext 0.36751f
C32 physical_preamp_n.sar_comparator_input m4_51060_36440# 0.12909f
C33 shared_converter_mux_0.mux_bus vdd_ext 0.00217f
C34 sar_readout_12b_0.vdd iso_tail_ext 0.27521f
C35 latch_sense_p_ext iso_tail_ext 0.1295f
C36 latch_sense_n_ext latch_sense_n_ext_uq1 0.13155f
C37 m4_45060_36440# vdd_ext 0.01404f
C38 shared_converter_mux_0.vss row_drive 0.00246f
C39 iso_tail_ext vdd_ext 0.86179f
C40 m1_68300_3080# row_drive 2.68328f
C41 physical_preamp_n.sar_comparator_input row_drive 0.12269f
C42 latch_sense_p_ext tail_ext 0.99589f
C43 iso_tail_ext sar_comparator_input 0.16721f
C44 physical_preamp_n.sar_comparator_input latch_sense_n_ext 0.08798f
C45 m4_45060_36440# latch_sense_n_ext_uq1 0.04583f
C46 iso_tail_ext latch_sense_n_ext_uq1 0.12999f
C47 decision_n vdd_ext 3.9382f
C48 latch_sense_p_ext eval 0.19752f
C49 vss row_drive 0.22445f
C50 shared_converter_mux_0.vss shared_converter_mux_0.mux_bus 1.56188f
C51 tail_ext vdd_ext 1.9856f
C52 reset decision_n 0.31048f
C53 reset tail_ext 0.17577f
C54 row_dac_10b_0.vss row_drive 1.08123f
C55 eval vdd_ext 0
C56 vss shared_converter_mux_0.vdd 0.2816f
C57 decision_n latch_sense_n_ext_uq1 0.37635f
C58 physical_preamp_p.latch_sense_p_ext vdd_ext 0.01185f
C59 sar_readout_12b_0.vdd sar_readout_12b_0.vss 0.49712f
C60 shared_converter_mux_0.vdd row_drive 0.00246f
C61 tail_ext latch_sense_n_ext_uq1 1.09601f
C62 vss shared_converter_mux_0.mux_bus 0.03132f
C63 shared_converter_mux_0.mux_bus row_drive 0.06281f
C64 sar_readout_12b_0.vss vdd_ext 0.93663f
C65 physical_preamp_p.latch_sense_p_ext latch_sense_n_ext_uq1 0.09914f
C66 sar_readout_12b_0.vdd vdd_ext 1.39936f
C67 m4_45060_36440# row_drive 0.13059f
C68 shared_converter_mux_0.vdd shared_converter_mux_0.mux_bus 1.55306f
C69 latch_sense_p_ext vdd_ext 4.11646f
C70 iso_tail_ext row_drive 2.39704f
C71 latch_sense_p_ext reset 0.19529f
C72 reset vdd_ext 4.48789f
C73 vss vss_escape 36.2394f
C74 vdd vss_escape 36.7f
C75 iso_tail_ext vss_escape 77.06784f
C76 latch_sense_p_ext vss_escape 47.08435f
C77 decision_p vss_escape 11.72151f
C78 tail_ext vss_escape 0.12174p
C79 latch_sense_n_ext_uq1 vss_escape 9.0153f
C80 vdd_ext vss_escape 0.26742p
C81 m4_51060_36440# vss_escape 0.11856f ; **FLOATING
C82 m4_45060_36440# vss_escape 0.10814f ; **FLOATING
C83 sar_readout_12b_0.vss vss_escape 1.33686f ; **FLOATING
C84 row_dac_10b_0.vss vss_escape 1.40333f ; **FLOATING
C85 row_dac_10b_0.vdd vss_escape 1.33457f ; **FLOATING
C86 sar_readout_12b_0.vdd vss_escape 1.77614f ; **FLOATING
C87 m1_68300_3080# vss_escape 7.89552f ; **FLOATING
C88 shared_converter_mux_0.vss vss_escape 1.39454f ; **FLOATING
C89 shared_converter_mux_0.mux_bus vss_escape 2.86922f ; **FLOATING
C90 shared_converter_mux_0.vdd vss_escape 0.95985f ; **FLOATING
C91 latch_sense_n_ext vss_escape 4.69839f
C92 physical_preamp_p.latch_sense_p_ext vss_escape 0.53398f
.ends
