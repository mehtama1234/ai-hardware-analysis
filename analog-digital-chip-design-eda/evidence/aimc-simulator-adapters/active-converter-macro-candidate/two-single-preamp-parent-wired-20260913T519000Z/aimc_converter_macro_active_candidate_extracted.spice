* NGSPICE file created from aimc_converter_macro_active_candidate_flat.ext - technology: sky130A

.subckt aimc_converter_macro_active_candidate_flat vss vdd row_drive sar_comparator_input
+ decision_p decision_n reset eval vss_escape latch_sense_p_ext latch_sense_n_ext
+ iso_tail_ext tail_ext vdd_ext
X0 latch_sense_n_ext sar_comparator_input preamp_iso_tail_ext vss_escape sky130_fd_pr__nfet_01v8 ad=3.36 pd=8 as=3.12 ps=7.6 w=1.2 l=0.6
X1 vdd_ext decision_p decision_n vdd_ext sky130_fd_pr__pfet_01v8 ad=3.12 pd=7.6 as=3.36 ps=8 w=1.2 l=0.6
X2 tail_ext eval vss_escape vss_escape sky130_fd_pr__nfet_01v8 ad=16.2 pd=17.4 as=16.2 ps=17.4 w=6 l=0.6
X3 decision_p latch_sense_p_ext tail_ext vss_escape sky130_fd_pr__nfet_01v8 ad=3.36 pd=8 as=3.12 ps=7.6 w=1.2 l=0.6
X4 vdd_ext reset decision_n vdd_ext sky130_fd_pr__pfet_01v8 ad=3.12 pd=7.6 as=3.36 ps=8 w=1.2 l=0.6
X5 tail_ext latch_sense_n_ext decision_n vss_escape sky130_fd_pr__nfet_01v8 ad=3.12 pd=7.6 as=3.36 ps=8 w=1.2 l=0.6
X6 decision_p decision_n vdd_ext vdd_ext sky130_fd_pr__pfet_01v8 ad=3.36 pd=8 as=3.12 ps=7.6 w=1.2 l=0.6
X7 tail_ext decision_p decision_n vss_escape sky130_fd_pr__nfet_01v8 ad=3.12 pd=7.6 as=3.36 ps=8 w=1.2 l=0.6
X8 latch_sense_p_ext row_drive iso_tail_ext vss_escape sky130_fd_pr__nfet_01v8 ad=3.36 pd=8 as=3.12 ps=7.6 w=1.2 l=0.6
X9 iso_tail_ext sar_comparator_input latch_sense_n_ext vss_escape sky130_fd_pr__nfet_01v8 ad=3.12 pd=7.6 as=3.36 ps=8 w=1.2 l=0.6
X10 latch_sense_p_ext row_drive preamp_iso_tail_ext vss_escape sky130_fd_pr__nfet_01v8 ad=3.36 pd=8 as=3.12 ps=7.6 w=1.2 l=0.6
X11 decision_p reset vdd_ext vdd_ext sky130_fd_pr__pfet_01v8 ad=3.36 pd=8 as=3.12 ps=7.6 w=1.2 l=0.6
X12 decision_p decision_n tail_ext vss_escape sky130_fd_pr__nfet_01v8 ad=3.36 pd=8 as=3.12 ps=7.6 w=1.2 l=0.6
C0 latch_sense_p_ext sar_comparator_input 0.09095f
C1 shared_converter_mux_0.vdd vss 0.2816f
C2 reset latch_sense_p_ext 0.19529f
C3 decision_n tail_ext 0.48065f
C4 row_dac_10b_0.vdd row_drive 1.11462f
C5 reset decision_p 0.376f
C6 row_dac_10b_0.vss row_dac_10b_0.vdd 0.78467f
C7 row_dac_10b_0.vss row_drive 1.08123f
C8 preamp_iso_tail_ext row_drive 0.08458f
C9 sar_readout_12b_0.vdd vdd_ext 1.39936f
C10 vdd_ext latch_sense_p_ext 5.38432f
C11 latch_sense_n_ext latch_sense_p_ext 0.59927f
C12 eval tail_ext 0.36751f
C13 m4_32000_38940# latch_sense_n_ext 0.0096f
C14 vdd_ext decision_p 3.8282f
C15 m1_68300_3080# sar_comparator_input 0.05195f
C16 vdd_ext shared_converter_mux_0.mux_bus 0.00217f
C17 vdd_ext shared_converter_mux_0.vss 0
C18 sar_readout_12b_0.vdd row_drive 0.58157f
C19 latch_sense_p_ext row_drive 1.32666f
C20 vss sar_comparator_input 0.05708f
C21 vdd_ext m1_68300_3080# 0.24419f
C22 preamp_iso_tail_ext latch_sense_p_ext 0.28327f
C23 shared_converter_mux_0.mux_bus row_drive 0.06281f
C24 shared_converter_mux_0.vss row_drive 0.00246f
C25 vdd_ext vss 0.19458f
C26 vss latch_sense_n_ext 0.29037f
C27 decision_n sar_comparator_input 0.17131f
C28 m1_68300_3080# row_drive 2.68328f
C29 reset decision_n 0.31048f
C30 reset tail_ext 0.17577f
C31 m4_32000_38940# latch_sense_p_ext 0.00354f
C32 decision_p latch_sense_p_ext 0.37635f
C33 vdd_ext decision_n 3.9382f
C34 vss row_drive 0.22445f
C35 decision_n latch_sense_n_ext 0.37635f
C36 vdd_ext tail_ext 1.9856f
C37 tail_ext latch_sense_n_ext 1.09601f
C38 vdd_ext eval 0
C39 shared_converter_mux_0.mux_bus shared_converter_mux_0.vss 1.56188f
C40 m4_45060_36440# sar_comparator_input 0.05954f
C41 sar_readout_12b_0.vss iso_tail_ext 0.60045f
C42 vdd_ext shared_converter_mux_0.vdd 0
C43 iso_tail_ext sar_comparator_input 0.16721f
C44 vss latch_sense_p_ext 0.29037f
C45 vdd_ext m4_45060_36440# 0.01404f
C46 shared_converter_mux_0.mux_bus vss 0.03132f
C47 shared_converter_mux_0.vdd row_drive 0.00246f
C48 vdd_ext sar_readout_12b_0.vss 0.93663f
C49 m2_42000_41940# row_drive 0.12051f
C50 vdd_ext iso_tail_ext 0.86179f
C51 iso_tail_ext latch_sense_n_ext 0.12999f
C52 tail_ext latch_sense_p_ext 0.99589f
C53 vdd_ext sar_comparator_input 1.73531f
C54 m4_45060_36440# row_drive 0.09499f
C55 latch_sense_n_ext sar_comparator_input 0.68401f
C56 vdd_ext reset 4.48789f
C57 decision_n decision_p 2.54301f
C58 eval latch_sense_p_ext 0.19752f
C59 tail_ext decision_p 0.48065f
C60 sar_readout_12b_0.vss row_drive 0.29433f
C61 iso_tail_ext row_drive 2.39704f
C62 vdd_ext latch_sense_n_ext 4.55721f
C63 sar_comparator_input row_drive 5.48055f
C64 shared_converter_mux_0.vdd shared_converter_mux_0.mux_bus 1.55306f
C65 preamp_iso_tail_ext sar_comparator_input 0.10537f
C66 m4_45060_36440# latch_sense_p_ext 0.00631f
C67 sar_readout_12b_0.vdd sar_readout_12b_0.vss 0.49712f
C68 vdd row_drive 0.1964f
C69 vdd_ext row_drive 5.04788f
C70 iso_tail_ext latch_sense_p_ext 0.1295f
C71 sar_readout_12b_0.vdd iso_tail_ext 0.27521f
C72 latch_sense_n_ext row_drive 0.81732f
C73 preamp_iso_tail_ext vdd_ext 0.01046f
C74 preamp_iso_tail_ext latch_sense_n_ext 0.36983f
C75 vss vss_escape 36.2394f
C76 vdd vss_escape 36.7f
C77 iso_tail_ext vss_escape 75.97121f
C78 decision_p vss_escape 13.13722f
C79 tail_ext vss_escape 0.13154p
C80 latch_sense_p_ext vss_escape 55.003f
C81 vdd_ext vss_escape 0.26363p
C82 m4_45060_36440# vss_escape 0.08796f ; **FLOATING
C83 m4_32000_38940# vss_escape 0.1568f ; **FLOATING
C84 m2_42000_41940# vss_escape 3.91591f ; **FLOATING
C85 sar_readout_12b_0.vss vss_escape 1.33686f ; **FLOATING
C86 row_dac_10b_0.vss vss_escape 1.40333f ; **FLOATING
C87 row_dac_10b_0.vdd vss_escape 1.33457f ; **FLOATING
C88 sar_readout_12b_0.vdd vss_escape 1.77614f ; **FLOATING
C89 m1_68300_3080# vss_escape 7.89552f ; **FLOATING
C90 shared_converter_mux_0.vss vss_escape 1.39454f ; **FLOATING
C91 shared_converter_mux_0.mux_bus vss_escape 2.86922f ; **FLOATING
C92 shared_converter_mux_0.vdd vss_escape 0.95985f ; **FLOATING
C93 preamp_iso_tail_ext vss_escape 23.44093f
.ends
