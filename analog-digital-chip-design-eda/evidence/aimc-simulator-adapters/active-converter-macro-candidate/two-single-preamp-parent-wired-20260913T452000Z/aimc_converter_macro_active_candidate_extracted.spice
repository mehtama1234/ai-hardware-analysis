* NGSPICE file created from aimc_converter_macro_active_candidate_flat.ext - technology: sky130A

.subckt aimc_converter_macro_active_candidate_flat vss vdd row_drive sar_comparator_input
+ decision_p decision_n reset eval vss_escape latch_sense_n_ext iso_tail_ext tail_ext
+ vdd_ext
X0 vdd_ext decision_p decision_n vdd_ext sky130_fd_pr__pfet_01v8 ad=3.12 pd=7.6 as=3.36 ps=8 w=1.2 l=0.6
X1 tail_ext eval vss_escape vss_escape sky130_fd_pr__nfet_01v8 ad=16.2 pd=17.4 as=16.2 ps=17.4 w=6 l=0.6
X2 latch_sense_n_ext sar_comparator_input row_drive vss_escape sky130_fd_pr__nfet_01v8 ad=3.36 pd=8 as=3.12 ps=7.6 w=1.2 l=0.6
X3 decision_p row_drive tail_ext vss_escape sky130_fd_pr__nfet_01v8 ad=3.36 pd=8 as=3.12 ps=7.6 w=1.2 l=0.6
X4 vdd_ext reset decision_n vdd_ext sky130_fd_pr__pfet_01v8 ad=3.12 pd=7.6 as=3.36 ps=8 w=1.2 l=0.6
X5 tail_ext latch_sense_n_ext decision_n vss_escape sky130_fd_pr__nfet_01v8 ad=3.12 pd=7.6 as=3.36 ps=8 w=1.2 l=0.6
X6 decision_p decision_n vdd_ext vdd_ext sky130_fd_pr__pfet_01v8 ad=3.36 pd=8 as=3.12 ps=7.6 w=1.2 l=0.6
X7 tail_ext decision_p decision_n vss_escape sky130_fd_pr__nfet_01v8 ad=3.12 pd=7.6 as=3.36 ps=8 w=1.2 l=0.6
X8 row_drive row_drive iso_tail_ext vss_escape sky130_fd_pr__nfet_01v8 ad=3.36 pd=8 as=3.12 ps=7.6 w=1.2 l=0.6
X9 iso_tail_ext sar_comparator_input latch_sense_n_ext vss_escape sky130_fd_pr__nfet_01v8 ad=3.12 pd=7.6 as=3.36 ps=8 w=1.2 l=0.6
X10 decision_p reset vdd_ext vdd_ext sky130_fd_pr__pfet_01v8 ad=3.36 pd=8 as=3.12 ps=7.6 w=1.2 l=0.6
X11 row_drive row_drive row_drive vss_escape sky130_fd_pr__nfet_01v8 ad=3.12 pd=7.6 as=12.96 ps=31.2 w=1.2 l=0.6
X12 decision_p decision_n tail_ext vss_escape sky130_fd_pr__nfet_01v8 ad=3.36 pd=8 as=3.12 ps=7.6 w=1.2 l=0.6
C0 decision_n decision_p 2.54301f
C1 iso_tail_ext vdd_ext 0.86179f
C2 vss shared_converter_mux_0.mux_bus 0.03132f
C3 row_dac_10b_0.vss row_dac_10b_0.vdd 0.78467f
C4 vdd_ext row_drive 7.70691f
C5 iso_tail_ext sar_readout_12b_0.vdd 0.27521f
C6 vdd_ext reset 4.48789f
C7 m1_68300_3080# row_drive 2.68328f
C8 sar_readout_12b_0.vdd row_drive 0.58157f
C9 decision_n reset 0.31048f
C10 shared_converter_mux_0.vdd vss 0.2816f
C11 vss sar_comparator_input 0.09437f
C12 shared_converter_mux_0.vdd shared_converter_mux_0.mux_bus 1.55306f
C13 row_dac_10b_0.vdd row_drive 1.11462f
C14 vdd_ext sar_readout_12b_0.vss 0.93663f
C15 iso_tail_ext latch_sense_n_ext 0.12577f
C16 tail_ext eval 0.36751f
C17 row_drive latch_sense_n_ext 0.94345f
C18 vdd_ext vss 0.19458f
C19 sar_readout_12b_0.vss sar_readout_12b_0.vdd 0.49712f
C20 tail_ext sar_comparator_input 0.21605f
C21 vdd_ext shared_converter_mux_0.mux_bus 0.00217f
C22 eval vdd_ext 0
C23 tail_ext vdd_ext 1.9856f
C24 row_dac_10b_0.vss row_drive 1.08123f
C25 shared_converter_mux_0.vdd vdd_ext 0
C26 tail_ext decision_n 0.48065f
C27 vdd_ext sar_comparator_input 1.59839f
C28 sar_comparator_input decision_n 0.27273f
C29 vss latch_sense_n_ext 0.23329f
C30 shared_converter_mux_0.vss row_drive 0.00246f
C31 decision_p row_drive 0.31086f
C32 sar_comparator_input m1_68300_3080# 0.05195f
C33 iso_tail_ext row_drive 2.52281f
C34 vdd row_drive 0.1964f
C35 decision_p reset 0.376f
C36 vdd_ext decision_n 3.9382f
C37 vdd_ext m1_68300_3080# 0.24419f
C38 tail_ext latch_sense_n_ext 0.0334f
C39 vdd_ext sar_readout_12b_0.vdd 1.39936f
C40 sar_comparator_input latch_sense_n_ext 0.47986f
C41 iso_tail_ext sar_readout_12b_0.vss 0.60045f
C42 sar_readout_12b_0.vss row_drive 0.29433f
C43 shared_converter_mux_0.mux_bus shared_converter_mux_0.vss 1.56188f
C44 vdd_ext latch_sense_n_ext 3.52709f
C45 vss row_drive 0.73578f
C46 decision_n latch_sense_n_ext 0.18428f
C47 shared_converter_mux_0.mux_bus row_drive 0.06281f
C48 tail_ext decision_p 0.48065f
C49 tail_ext row_drive 0.07814f
C50 iso_tail_ext sar_comparator_input 0.16721f
C51 shared_converter_mux_0.vdd row_drive 0.00246f
C52 sar_comparator_input row_drive 6.96384f
C53 tail_ext reset 0.17577f
C54 vdd_ext shared_converter_mux_0.vss 0
C55 vdd_ext decision_p 3.8282f
C56 vss vss_escape 36.1986f
C57 vdd vss_escape 36.7f
C58 iso_tail_ext vss_escape 20.9682f
C59 decision_p vss_escape 21.48749f
C60 tail_ext vss_escape 0.18376p
C61 vdd_ext vss_escape 0.26108p
C62 sar_readout_12b_0.vss vss_escape 1.33686f ; **FLOATING
C63 row_dac_10b_0.vss vss_escape 1.40333f ; **FLOATING
C64 row_dac_10b_0.vdd vss_escape 1.33457f ; **FLOATING
C65 sar_readout_12b_0.vdd vss_escape 1.77614f ; **FLOATING
C66 m1_68300_3080# vss_escape 7.89552f ; **FLOATING
C67 shared_converter_mux_0.vss vss_escape 1.39454f ; **FLOATING
C68 shared_converter_mux_0.mux_bus vss_escape 2.86922f ; **FLOATING
C69 shared_converter_mux_0.vdd vss_escape 0.95985f ; **FLOATING
.ends
