* NGSPICE file created from aimc_converter_macro_active_candidate_flat.ext - technology: sky130A

.subckt aimc_converter_macro_active_candidate_flat vss vdd row_drive sar_comparator_input
+ decision_p decision_n reset eval vss_escape latch_sense_n_ext iso_tail_ext tail_ext
+ vdd_ext
X0 vdd_ext decision_p decision_n vdd_ext sky130_fd_pr__pfet_01v8 ad=3.12 pd=7.6 as=3.36 ps=8 w=1.2 l=0.6
X1 tail_ext eval vss_escape vss_escape sky130_fd_pr__nfet_01v8 ad=16.2 pd=17.4 as=16.2 ps=17.4 w=6 l=0.6
X2 latch_sense_n_ext sar_comparator_input vdd_ext vss_escape sky130_fd_pr__nfet_01v8 ad=3.36 pd=8 as=3.12 ps=7.6 w=1.2 l=0.6
X3 decision_p vdd_ext tail_ext vss_escape sky130_fd_pr__nfet_01v8 ad=3.36 pd=8 as=3.12 ps=7.6 w=1.2 l=0.6
X4 vdd_ext reset decision_n vdd_ext sky130_fd_pr__pfet_01v8 ad=3.12 pd=7.6 as=3.36 ps=8 w=1.2 l=0.6
X5 tail_ext latch_sense_n_ext decision_n vss_escape sky130_fd_pr__nfet_01v8 ad=3.12 pd=7.6 as=3.36 ps=8 w=1.2 l=0.6
X6 decision_p decision_n vdd_ext vdd_ext sky130_fd_pr__pfet_01v8 ad=3.36 pd=8 as=3.12 ps=7.6 w=1.2 l=0.6
X7 tail_ext decision_p decision_n vss_escape sky130_fd_pr__nfet_01v8 ad=3.12 pd=7.6 as=3.36 ps=8 w=1.2 l=0.6
X8 vdd_ext row_drive iso_tail_ext vss_escape sky130_fd_pr__nfet_01v8 ad=3.36 pd=8 as=3.12 ps=7.6 w=1.2 l=0.6
X9 iso_tail_ext sar_comparator_input latch_sense_n_ext vss_escape sky130_fd_pr__nfet_01v8 ad=3.12 pd=7.6 as=3.36 ps=8 w=1.2 l=0.6
X10 decision_p reset vdd_ext vdd_ext sky130_fd_pr__pfet_01v8 ad=3.36 pd=8 as=3.12 ps=7.6 w=1.2 l=0.6
X11 vdd_ext row_drive vdd_ext vss_escape sky130_fd_pr__nfet_01v8 ad=3.12 pd=7.6 as=15.36 ps=44 w=1.2 l=0.6
X12 decision_p decision_n tail_ext vss_escape sky130_fd_pr__nfet_01v8 ad=3.36 pd=8 as=3.12 ps=7.6 w=1.2 l=0.6
C0 vss row_drive 0.44137f
C1 sar_comparator_input m1_68300_3080# 0.05195f
C2 iso_tail_ext latch_sense_n_ext 0.12577f
C3 decision_p reset 0.376f
C4 shared_converter_mux_0.mux_bus shared_converter_mux_0.vss 1.56188f
C5 vdd_ext decision_n 3.9382f
C6 vdd_ext m1_68300_3080# 0.24419f
C7 tail_ext row_drive 0.04474f
C8 vdd_ext sar_readout_12b_0.vdd 1.39936f
C9 shared_converter_mux_0.vdd row_drive 0.00246f
C10 sar_comparator_input row_drive 5.46697f
C11 iso_tail_ext sar_readout_12b_0.vss 0.60045f
C12 vdd_ext row_drive 6.28027f
C13 vss latch_sense_n_ext 0.23329f
C14 m1_68300_3080# row_drive 2.68328f
C15 sar_readout_12b_0.vdd row_drive 0.58157f
C16 shared_converter_mux_0.mux_bus vss 0.03132f
C17 tail_ext decision_p 0.48065f
C18 row_dac_10b_0.vdd row_drive 1.11462f
C19 tail_ext latch_sense_n_ext 0.0334f
C20 iso_tail_ext sar_comparator_input 0.16721f
C21 sar_comparator_input latch_sense_n_ext 0.49873f
C22 tail_ext reset 0.17577f
C23 vdd_ext shared_converter_mux_0.vss 0
C24 vdd_ext decision_p 4.01248f
C25 shared_converter_mux_0.vdd shared_converter_mux_0.mux_bus 1.55306f
C26 decision_n decision_p 2.54301f
C27 iso_tail_ext vdd_ext 0.98756f
C28 row_dac_10b_0.vss row_dac_10b_0.vdd 0.78467f
C29 vdd_ext latch_sense_n_ext 3.62785f
C30 decision_n latch_sense_n_ext 0.18428f
C31 iso_tail_ext sar_readout_12b_0.vdd 0.27521f
C32 vdd_ext reset 4.48789f
C33 row_dac_10b_0.vss row_drive 1.08123f
C34 vdd_ext shared_converter_mux_0.mux_bus 0.00217f
C35 decision_n reset 0.31048f
C36 shared_converter_mux_0.vdd vss 0.2816f
C37 vss sar_comparator_input 0.09437f
C38 shared_converter_mux_0.vss row_drive 0.00246f
C39 decision_p row_drive 0.02173f
C40 vdd_ext sar_readout_12b_0.vss 0.93663f
C41 iso_tail_ext row_drive 2.39704f
C42 vdd row_drive 0.1964f
C43 tail_ext eval 0.36751f
C44 latch_sense_n_ext row_drive 0.61034f
C45 vdd_ext vss 0.52173f
C46 sar_readout_12b_0.vss sar_readout_12b_0.vdd 0.49712f
C47 tail_ext sar_comparator_input 0.21605f
C48 shared_converter_mux_0.mux_bus row_drive 0.06281f
C49 eval vdd_ext 0
C50 tail_ext vdd_ext 2.019f
C51 shared_converter_mux_0.vdd vdd_ext 0
C52 sar_readout_12b_0.vss row_drive 0.29433f
C53 tail_ext decision_n 0.48065f
C54 vdd_ext sar_comparator_input 2.97528f
C55 sar_comparator_input decision_n 0.27273f
C56 vss vss_escape 36.1986f
C57 vdd vss_escape 36.7f
C58 iso_tail_ext vss_escape 61.09725f
C59 decision_p vss_escape 39.74691f
C60 tail_ext vss_escape 0.31162p
C61 vdd_ext vss_escape 74.52187f
C62 sar_readout_12b_0.vss vss_escape 1.33686f ; **FLOATING
C63 row_dac_10b_0.vss vss_escape 1.40333f ; **FLOATING
C64 row_dac_10b_0.vdd vss_escape 1.33457f ; **FLOATING
C65 sar_readout_12b_0.vdd vss_escape 1.77614f ; **FLOATING
C66 m1_68300_3080# vss_escape 7.89552f ; **FLOATING
C67 shared_converter_mux_0.vss vss_escape 1.39454f ; **FLOATING
C68 shared_converter_mux_0.mux_bus vss_escape 2.86922f ; **FLOATING
C69 shared_converter_mux_0.vdd vss_escape 0.95985f ; **FLOATING
.ends
