* NGSPICE file created from aimc_converter_macro_active_candidate_flat.ext - technology: sky130A

.subckt aimc_converter_macro_active_candidate_flat vss vdd row_drive sar_comparator_input
+ decision_p reset eval vss_escape latch_sense_p_ext iso_tail_ext vdd_ext
X0 vdd_ext physical_preamp_n.gate preamp_iso_tail_ext vss_escape sky130_fd_pr__nfet_01v8 ad=3.36 pd=8 as=3.12 ps=7.6 w=1.2 l=0.6
X1 vdd_ext decision_p vdd_ext vdd_ext sky130_fd_pr__pfet_01v8 ad=3.36 pd=8 as=19.2 ps=46.4 w=1.2 l=0.6
X2 vdd_ext eval vss_escape vss_escape sky130_fd_pr__nfet_01v8 ad=16.2 pd=17.4 as=16.2 ps=17.4 w=6 l=0.6
X3 decision_p latch_sense_p_ext vdd_ext vss_escape sky130_fd_pr__nfet_01v8 ad=3.36 pd=8 as=3.12 ps=7.6 w=1.2 l=0.6
X4 vdd_ext reset vdd_ext vdd_ext sky130_fd_pr__pfet_01v8 ad=3.36 pd=8 as=0 ps=0 w=1.2 l=0.6
X5 vdd_ext vdd_ext vdd_ext vss_escape sky130_fd_pr__nfet_01v8 ad=3.36 pd=8 as=44.52 ps=92.6 w=1.2 l=0.6
X6 decision_p vdd_ext vdd_ext vdd_ext sky130_fd_pr__pfet_01v8 ad=3.36 pd=8 as=3.12 ps=7.6 w=1.2 l=0.6
X7 vdd_ext decision_p vdd_ext vss_escape sky130_fd_pr__nfet_01v8 ad=3.36 pd=8 as=0 ps=0 w=1.2 l=0.6
X8 latch_sense_p_ext row_drive iso_tail_ext vss_escape sky130_fd_pr__nfet_01v8 ad=3.36 pd=8 as=3.12 ps=7.6 w=1.2 l=0.6
X9 iso_tail_ext sar_comparator_input vdd_ext vss_escape sky130_fd_pr__nfet_01v8 ad=3.12 pd=7.6 as=3.36 ps=8 w=1.2 l=0.6
X10 physical_preamp_p.drain row_drive preamp_iso_tail_ext vss_escape sky130_fd_pr__nfet_01v8 ad=3.36 pd=8 as=3.12 ps=7.6 w=1.2 l=0.6
X11 decision_p reset vdd_ext vdd_ext sky130_fd_pr__pfet_01v8 ad=3.36 pd=8 as=3.12 ps=7.6 w=1.2 l=0.6
X12 decision_p vdd_ext vdd_ext vss_escape sky130_fd_pr__nfet_01v8 ad=3.36 pd=8 as=3.12 ps=7.6 w=1.2 l=0.6
C0 row_drive sar_comparator_input 5.22878f
C1 vdd_ext reset 4.97414f
C2 row_drive shared_converter_mux_0.mux_bus 0.06281f
C3 row_drive m4_45060_36440# 0.13059f
C4 row_drive physical_preamp_p.drain 0.08798f
C5 vdd_ext row_drive 4.73718f
C6 vdd_ext latch_sense_p_ext 5.10823f
C7 shared_converter_mux_0.vdd vss 0.2816f
C8 row_drive sar_readout_12b_0.vss 0.29433f
C9 preamp_iso_tail_ext row_drive 0.43607f
C10 vdd_ext eval 0.36809f
C11 physical_preamp_n.gate vdd_ext 0.30883f
C12 latch_sense_p_ext reset 0.19529f
C13 row_drive vdd 0.1964f
C14 physical_preamp_n.gate preamp_iso_tail_ext 0.52228f
C15 row_drive latch_sense_p_ext 0.70701f
C16 shared_converter_mux_0.mux_bus vss 0.03132f
C17 sar_readout_12b_0.vdd iso_tail_ext 0.27521f
C18 vdd_ext decision_p 6.85185f
C19 shared_converter_mux_0.mux_bus shared_converter_mux_0.vss 1.56188f
C20 vdd_ext m4_51060_36440# 0.01404f
C21 vdd_ext vss 0.50086f
C22 vdd_ext shared_converter_mux_0.vss 0
C23 vdd_ext m1_68300_3080# 0.24419f
C24 row_dac_10b_0.vdd row_drive 1.11462f
C25 row_dac_10b_0.vss row_drive 1.08123f
C26 latch_sense_p_ext eval 0.19752f
C27 physical_preamp_n.gate row_drive 0.12269f
C28 preamp_iso_tail_ext m4_51060_36440# 0.00179f
C29 vdd_ext sar_readout_12b_0.vdd 1.39936f
C30 decision_p reset 0.376f
C31 shared_converter_mux_0.vdd shared_converter_mux_0.mux_bus 1.55306f
C32 sar_readout_12b_0.vss sar_readout_12b_0.vdd 0.49712f
C33 row_dac_10b_0.vss row_dac_10b_0.vdd 0.78467f
C34 vdd_ext shared_converter_mux_0.vdd 0
C35 latch_sense_p_ext decision_p 0.37635f
C36 sar_comparator_input iso_tail_ext 0.16721f
C37 row_drive vss 0.22445f
C38 vss latch_sense_p_ext 0.29037f
C39 row_drive shared_converter_mux_0.vss 0.00246f
C40 row_drive m1_68300_3080# 2.68328f
C41 vdd_ext iso_tail_ext 0.98756f
C42 row_drive sar_readout_12b_0.vdd 0.58157f
C43 vdd_ext sar_comparator_input 1.10959f
C44 physical_preamp_n.gate m4_51060_36440# 0.13059f
C45 sar_readout_12b_0.vss iso_tail_ext 0.60045f
C46 vdd_ext shared_converter_mux_0.mux_bus 0.00217f
C47 row_drive shared_converter_mux_0.vdd 0.00246f
C48 vdd_ext m4_45060_36440# 0.01404f
C49 vdd_ext physical_preamp_p.drain 0.02222f
C50 preamp_iso_tail_ext m4_45060_36440# 0.04583f
C51 preamp_iso_tail_ext physical_preamp_p.drain 0.09782f
C52 vdd_ext sar_readout_12b_0.vss 0.93663f
C53 vdd_ext preamp_iso_tail_ext 0.63713f
C54 row_drive iso_tail_ext 2.39704f
C55 iso_tail_ext latch_sense_p_ext 0.1295f
C56 vss vss_escape 36.2394f
C57 vdd vss_escape 36.7f
C58 iso_tail_ext vss_escape 77.06784f
C59 latch_sense_p_ext vss_escape 47.08435f
C60 decision_p vss_escape 10.1717f
C61 m4_51060_36440# vss_escape 0.13014f ; **FLOATING
C62 m4_45060_36440# vss_escape 0.10814f ; **FLOATING
C63 sar_readout_12b_0.vss vss_escape 1.33686f ; **FLOATING
C64 row_dac_10b_0.vss vss_escape 1.40333f ; **FLOATING
C65 row_dac_10b_0.vdd vss_escape 1.33457f ; **FLOATING
C66 sar_readout_12b_0.vdd vss_escape 1.77614f ; **FLOATING
C67 m1_68300_3080# vss_escape 7.89552f ; **FLOATING
C68 shared_converter_mux_0.vss vss_escape 1.39454f ; **FLOATING
C69 shared_converter_mux_0.mux_bus vss_escape 2.86922f ; **FLOATING
C70 shared_converter_mux_0.vdd vss_escape 0.95985f ; **FLOATING
C71 physical_preamp_p.drain vss_escape 0.57823f
C72 preamp_iso_tail_ext vss_escape 16.55566f
.ends
