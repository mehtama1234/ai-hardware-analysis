* NGSPICE file created from aimc_converter_macro_active_candidate_flat.ext - technology: sky130A

.subckt aimc_converter_macro_active_candidate_flat vss vdd row_drive sar_comparator_input
+ decision_p decision_n reset eval vss_escape latch_sense_p_ext iso_tail_ext tail_ext
+ vdd_ext latch_sense_n_ext_uq1
X0 latch_sense_n_ext physical_preamp_n.sar_comparator_input latch_sense_n_ext_uq1 vss_escape sky130_fd_pr__nfet_01v8 ad=3.36 pd=8 as=3.12 ps=7.6 w=1.2 l=0.6
X1 vdd_ext decision_p decision_n vdd_ext sky130_fd_pr__pfet_01v8 ad=3.12 pd=7.6 as=3.36 ps=8 w=1.2 l=0.6
X2 tail_ext eval vss_escape vss_escape sky130_fd_pr__nfet_01v8 ad=16.2 pd=17.4 as=16.2 ps=17.4 w=6 l=0.6
X3 decision_p latch_sense_p_ext tail_ext vss_escape sky130_fd_pr__nfet_01v8 ad=3.36 pd=8 as=3.12 ps=7.6 w=1.2 l=0.6
X4 vdd_ext reset decision_n vdd_ext sky130_fd_pr__pfet_01v8 ad=3.12 pd=7.6 as=3.36 ps=8 w=1.2 l=0.6
X5 tail_ext latch_sense_n_ext_uq1 decision_n vss_escape sky130_fd_pr__nfet_01v8 ad=3.12 pd=7.6 as=3.36 ps=8 w=1.2 l=0.6
X6 decision_p decision_n vdd_ext vdd_ext sky130_fd_pr__pfet_01v8 ad=3.36 pd=8 as=3.12 ps=7.6 w=1.2 l=0.6
X7 tail_ext decision_p decision_n vss_escape sky130_fd_pr__nfet_01v8 ad=3.12 pd=7.6 as=3.36 ps=8 w=1.2 l=0.6
X8 latch_sense_p_ext row_drive iso_tail_ext vss_escape sky130_fd_pr__nfet_01v8 ad=3.36 pd=8 as=3.12 ps=7.6 w=1.2 l=0.6
X9 iso_tail_ext sar_comparator_input latch_sense_n_ext_uq1 vss_escape sky130_fd_pr__nfet_01v8 ad=3.12 pd=7.6 as=3.36 ps=8 w=1.2 l=0.6
X10 physical_preamp_p.latch_sense_p_ext row_drive latch_sense_n_ext_uq1 vss_escape sky130_fd_pr__nfet_01v8 ad=3.36 pd=8 as=3.12 ps=7.6 w=1.2 l=0.6
X11 decision_p reset vdd_ext vdd_ext sky130_fd_pr__pfet_01v8 ad=3.36 pd=8 as=3.12 ps=7.6 w=1.2 l=0.6
X12 decision_p decision_n tail_ext vss_escape sky130_fd_pr__nfet_01v8 ad=3.36 pd=8 as=3.12 ps=7.6 w=1.2 l=0.6
C0 iso_tail_ext sar_comparator_input 0.16721f
C1 latch_sense_p_ext tail_ext 0.99589f
C2 physical_preamp_n.sar_comparator_input latch_sense_n_ext 0.1174f
C3 m4_45060_36440# latch_sense_n_ext_uq1 0.04583f
C4 iso_tail_ext latch_sense_n_ext_uq1 0.12999f
C5 decision_n vdd_ext 3.9382f
C6 latch_sense_p_ext eval 0.19752f
C7 vss row_drive 0.22445f
C8 shared_converter_mux_0.vss shared_converter_mux_0.mux_bus 1.56188f
C9 tail_ext vdd_ext 1.9856f
C10 reset decision_n 0.31048f
C11 reset tail_ext 0.17577f
C12 row_dac_10b_0.vss row_drive 1.08123f
C13 eval vdd_ext 0
C14 vss shared_converter_mux_0.vdd 0.2816f
C15 decision_n latch_sense_n_ext_uq1 0.37635f
C16 physical_preamp_p.latch_sense_p_ext vdd_ext 0.01185f
C17 sar_readout_12b_0.vdd sar_readout_12b_0.vss 0.49712f
C18 shared_converter_mux_0.vdd row_drive 0.00246f
C19 tail_ext latch_sense_n_ext_uq1 1.09601f
C20 vss shared_converter_mux_0.mux_bus 0.03132f
C21 shared_converter_mux_0.mux_bus row_drive 0.06281f
C22 sar_readout_12b_0.vss vdd_ext 0.93663f
C23 physical_preamp_p.latch_sense_p_ext latch_sense_n_ext_uq1 0.09914f
C24 sar_readout_12b_0.vdd vdd_ext 1.39936f
C25 m4_45060_36440# row_drive 0.13059f
C26 shared_converter_mux_0.vdd shared_converter_mux_0.mux_bus 1.55306f
C27 latch_sense_p_ext vdd_ext 4.11646f
C28 iso_tail_ext row_drive 2.39704f
C29 latch_sense_p_ext reset 0.19529f
C30 reset vdd_ext 4.48789f
C31 sar_comparator_input vdd_ext 1.06679f
C32 latch_sense_n_ext_uq1 vdd_ext 4.71191f
C33 decision_n decision_p 2.54301f
C34 tail_ext decision_p 0.48065f
C35 physical_preamp_p.latch_sense_p_ext row_drive 0.08419f
C36 row_dac_10b_0.vdd row_drive 1.11462f
C37 sar_comparator_input latch_sense_n_ext_uq1 0.04367f
C38 row_dac_10b_0.vss row_dac_10b_0.vdd 0.78467f
C39 shared_converter_mux_0.vss vdd_ext 0
C40 m1_68300_3080# vdd_ext 0.24419f
C41 physical_preamp_n.sar_comparator_input vdd_ext 0.01545f
C42 sar_readout_12b_0.vss row_drive 0.29433f
C43 m4_51060_36440# vdd_ext 0.01404f
C44 vss latch_sense_p_ext 0.29037f
C45 sar_readout_12b_0.vdd row_drive 0.58157f
C46 latch_sense_p_ext row_drive 0.70701f
C47 physical_preamp_n.sar_comparator_input latch_sense_n_ext_uq1 0.38422f
C48 vss vdd_ext 0.19458f
C49 m4_51060_36440# latch_sense_n_ext_uq1 0.00179f
C50 latch_sense_p_ext decision_p 0.37635f
C51 row_drive vdd_ext 3.84053f
C52 vdd row_drive 0.1964f
C53 decision_p vdd_ext 3.8282f
C54 decision_n tail_ext 0.48065f
C55 reset decision_p 0.376f
C56 latch_sense_n_ext vdd_ext 0.01216f
C57 vss latch_sense_n_ext_uq1 0.29037f
C58 shared_converter_mux_0.vdd vdd_ext 0
C59 sar_comparator_input row_drive 5.22878f
C60 iso_tail_ext sar_readout_12b_0.vss 0.60045f
C61 latch_sense_n_ext_uq1 row_drive 1.18654f
C62 eval tail_ext 0.36751f
C63 physical_preamp_n.sar_comparator_input m4_51060_36440# 0.13059f
C64 shared_converter_mux_0.mux_bus vdd_ext 0.00217f
C65 sar_readout_12b_0.vdd iso_tail_ext 0.27521f
C66 latch_sense_p_ext iso_tail_ext 0.1295f
C67 latch_sense_n_ext latch_sense_n_ext_uq1 0.15763f
C68 shared_converter_mux_0.vss row_drive 0.00246f
C69 m4_45060_36440# vdd_ext 0.01404f
C70 iso_tail_ext vdd_ext 0.86179f
C71 m1_68300_3080# row_drive 2.68328f
C72 physical_preamp_n.sar_comparator_input row_drive 0.12269f
C73 vss vss_escape 36.2394f
C74 vdd vss_escape 36.7f
C75 iso_tail_ext vss_escape 77.06784f
C76 latch_sense_p_ext vss_escape 47.08435f
C77 decision_p vss_escape 11.41912f
C78 tail_ext vss_escape 0.11841p
C79 latch_sense_n_ext_uq1 vss_escape 9.0153f
C80 vdd_ext vss_escape 0.26621p
C81 m4_51060_36440# vss_escape 0.13014f ; **FLOATING
C82 m4_45060_36440# vss_escape 0.10814f ; **FLOATING
C83 sar_readout_12b_0.vss vss_escape 1.33686f ; **FLOATING
C84 row_dac_10b_0.vss vss_escape 1.40333f ; **FLOATING
C85 row_dac_10b_0.vdd vss_escape 1.33457f ; **FLOATING
C86 sar_readout_12b_0.vdd vss_escape 1.77614f ; **FLOATING
C87 m1_68300_3080# vss_escape 7.89552f ; **FLOATING
C88 shared_converter_mux_0.vss vss_escape 1.39454f ; **FLOATING
C89 shared_converter_mux_0.mux_bus vss_escape 2.86922f ; **FLOATING
C90 shared_converter_mux_0.vdd vss_escape 0.95985f ; **FLOATING
C91 latch_sense_n_ext vss_escape 5.78341f
C92 physical_preamp_p.latch_sense_p_ext vss_escape 0.53398f
.ends
