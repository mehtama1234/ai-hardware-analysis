* NGSPICE file created from preamp_port_candidate.ext - technology: sky130A

.subckt preamp_port_candidate preamp_iso_tail_ext latch_sense_p_ext latch_sense_n_ext
+ row_drive sar_comparator_input vss_escape
X0 preamp_iso_tail_ext sar_comparator_input latch_sense_n_ext vss_escape sky130_fd_pr__nfet_01v8 ad=3.12 pd=7.6 as=3.36 ps=8 w=1.2 l=0.6
X1 latch_sense_p_ext row_drive preamp_iso_tail_ext vss_escape sky130_fd_pr__nfet_01v8 ad=3.36 pd=8 as=3.12 ps=7.6 w=1.2 l=0.6
C0 latch_sense_n_ext m2_900_1400# 0.41846f
C1 latch_sense_p_ext row_drive 0.02307f
C2 latch_sense_n_ext sar_comparator_input 0.02307f
C3 preamp_iso_tail_ext latch_sense_p_ext 0.05749f
C4 sar_comparator_input m2_900_1400# 0.0542f
C5 row_drive m2_900_1400# 0.0542f
C6 latch_sense_n_ext preamp_iso_tail_ext 0.05717f
C7 preamp_iso_tail_ext m2_900_1400# 0.34398f
C8 preamp_iso_tail_ext sar_comparator_input 0.11329f
C9 preamp_iso_tail_ext row_drive 0.12442f
C10 latch_sense_n_ext latch_sense_p_ext 0.00782f
C11 latch_sense_p_ext m2_900_1400# 0.41846f
C12 latch_sense_n_ext vss_escape 1.31695f
C13 latch_sense_p_ext vss_escape 1.31695f
C14 preamp_iso_tail_ext vss_escape 4.77505f
C15 m2_900_1400# vss_escape 1.01648f ; **FLOATING
.ends
