* NGSPICE file created from aimc_converter_macro_active_candidate_flat.ext - technology: sky130A

.subckt aimc_converter_macro_active_candidate_flat vss vdd row_drive decision_p decision_n
+ reset eval vss_escape latch_sense_p_ext latch_sense_n_ext iso_tail_ext tail_ext
+ vdd_ext
X0 row_drive physical_preamp_0.sense_n physical_preamp_0.iso_n vss_escape sky130_fd_pr__nfet_01v8 ad=3.12 pd=7.6 as=3.36 ps=8 w=1.2 l=0.6
X1 vdd_ext decision_p decision_n vdd_ext sky130_fd_pr__pfet_01v8 ad=3.12 pd=7.6 as=3.36 ps=8 w=1.2 l=0.6
X2 tail_ext eval vss_escape vss_escape sky130_fd_pr__nfet_01v8 ad=16.2 pd=17.4 as=16.2 ps=17.4 w=6 l=0.6
X3 physical_preamp_0.iso_p physical_preamp_0.sense_p row_drive vss_escape sky130_fd_pr__nfet_01v8 ad=3.36 pd=8 as=3.12 ps=7.6 w=1.2 l=0.6
X4 decision_p latch_sense_p_ext tail_ext vss_escape sky130_fd_pr__nfet_01v8 ad=3.36 pd=8 as=3.12 ps=7.6 w=1.2 l=0.6
X5 vdd_ext reset decision_n vdd_ext sky130_fd_pr__pfet_01v8 ad=3.12 pd=7.6 as=3.36 ps=8 w=1.2 l=0.6
X6 tail_ext latch_sense_n_ext decision_n vss_escape sky130_fd_pr__nfet_01v8 ad=3.12 pd=7.6 as=3.36 ps=8 w=1.2 l=0.6
X7 decision_p decision_n vdd_ext vdd_ext sky130_fd_pr__pfet_01v8 ad=3.36 pd=8 as=3.12 ps=7.6 w=1.2 l=0.6
X8 tail_ext decision_p decision_n vss_escape sky130_fd_pr__nfet_01v8 ad=3.12 pd=7.6 as=3.36 ps=8 w=1.2 l=0.6
X9 latch_sense_p_ext row_drive iso_tail_ext vss_escape sky130_fd_pr__nfet_01v8 ad=3.36 pd=8 as=3.12 ps=7.6 w=1.2 l=0.6
X10 iso_tail_ext row_drive latch_sense_n_ext vss_escape sky130_fd_pr__nfet_01v8 ad=3.12 pd=7.6 as=3.36 ps=8 w=1.2 l=0.6
X11 decision_p reset vdd_ext vdd_ext sky130_fd_pr__pfet_01v8 ad=3.36 pd=8 as=3.12 ps=7.6 w=1.2 l=0.6
X12 decision_p decision_n tail_ext vss_escape sky130_fd_pr__nfet_01v8 ad=3.36 pd=8 as=3.12 ps=7.6 w=1.2 l=0.6
C0 physical_preamp_0.iso_p row_drive 0.12625f
C1 sar_readout_12b_0.vss vdd_ext 0.93663f
C2 m2_64900_1400# physical_preamp_0.iso_p 0.40787f
C3 vdd_ext row_drive 4.83163f
C4 m2_64900_1400# vdd_ext 0.07254f
C5 decision_p vdd_ext 3.8282f
C6 latch_sense_p_ext row_drive 0.24412f
C7 latch_sense_n_ext iso_tail_ext 0.12577f
C8 decision_n decision_p 2.54301f
C9 latch_sense_p_ext decision_p 0.18428f
C10 shared_converter_mux_0.mux_bus vss 0.03132f
C11 decision_p tail_ext 0.48065f
C12 shared_converter_mux_0.vss vdd_ext 0
C13 physical_preamp_0.sense_p row_drive 0.40786f
C14 sar_readout_12b_0.vdd vdd_ext 1.39936f
C15 latch_sense_n_ext vss 0.23329f
C16 eval vdd_ext 0
C17 sar_readout_12b_0.vss iso_tail_ext 0.60045f
C18 iso_tail_ext row_drive 2.14683f
C19 physical_preamp_0.iso_p physical_preamp_0.iso_n 0.00782f
C20 shared_converter_mux_0.mux_bus row_drive 0.06281f
C21 vdd_ext physical_preamp_0.iso_n 0.0106f
C22 row_dac_10b_0.vdd row_drive 1.11462f
C23 vdd_ext shared_converter_mux_0.vdd 0
C24 eval tail_ext 0.36751f
C25 latch_sense_n_ext row_drive 0.24379f
C26 vss row_drive 0.22445f
C27 physical_preamp_0.sense_n vdd_ext 0.00183f
C28 shared_converter_mux_0.mux_bus shared_converter_mux_0.vss 1.56188f
C29 sar_readout_12b_0.vdd iso_tail_ext 0.27521f
C30 vdd_ext reset 4.48789f
C31 row_dac_10b_0.vss row_dac_10b_0.vdd 0.78467f
C32 decision_n reset 0.31048f
C33 sar_readout_12b_0.vss row_drive 0.29422f
C34 m2_64900_1400# row_drive 0.97298f
C35 tail_ext reset 0.17577f
C36 shared_converter_mux_0.mux_bus shared_converter_mux_0.vdd 1.55306f
C37 shared_converter_mux_0.vss row_drive 0.00246f
C38 shared_converter_mux_0.vdd vss 0.2816f
C39 sar_readout_12b_0.vdd sar_readout_12b_0.vss 0.49712f
C40 sar_readout_12b_0.vdd row_drive 0.57218f
C41 row_dac_10b_0.vss row_drive 1.08123f
C42 vdd row_drive 0.1964f
C43 vdd_ext physical_preamp_0.iso_p 0.02433f
C44 physical_preamp_0.iso_n row_drive 0.1264f
C45 m2_64900_1400# physical_preamp_0.iso_n 0.40787f
C46 decision_n vdd_ext 3.9382f
C47 shared_converter_mux_0.vdd row_drive 0.00246f
C48 latch_sense_p_ext vdd_ext 3.43095f
C49 vdd_ext tail_ext 1.9856f
C50 decision_n tail_ext 0.48065f
C51 physical_preamp_0.sense_n row_drive 0.38798f
C52 latch_sense_p_ext tail_ext 0.0334f
C53 physical_preamp_0.sense_p physical_preamp_0.iso_p 0.00681f
C54 physical_preamp_0.sense_p vdd_ext 0.00783f
C55 vdd_ext iso_tail_ext 0.86179f
C56 decision_p reset 0.376f
C57 shared_converter_mux_0.mux_bus vdd_ext 0.00217f
C58 latch_sense_p_ext iso_tail_ext 0.12577f
C59 latch_sense_n_ext vdd_ext 3.48444f
C60 vdd_ext vss 0.21361f
C61 decision_n latch_sense_n_ext 0.18428f
C62 physical_preamp_0.sense_n physical_preamp_0.iso_n 0.00681f
C63 latch_sense_p_ext vss 0.23329f
C64 latch_sense_n_ext tail_ext 0.0334f
C65 vss vss_escape 36.2211f
C66 vdd vss_escape 36.7f
C67 iso_tail_ext vss_escape 64.03416f
C68 latch_sense_p_ext vss_escape 41.98586f
C69 decision_p vss_escape 7.45999f
C70 tail_ext vss_escape 81.67176f
C71 vdd_ext vss_escape 0.25933p
C72 m2_64900_1400# vss_escape 0.68739f ; **FLOATING
C73 sar_readout_12b_0.vss vss_escape 1.33686f ; **FLOATING
C74 row_dac_10b_0.vss vss_escape 1.40333f ; **FLOATING
C75 row_dac_10b_0.vdd vss_escape 1.33457f ; **FLOATING
C76 sar_readout_12b_0.vdd vss_escape 1.77614f ; **FLOATING
C77 shared_converter_mux_0.vss vss_escape 1.39454f ; **FLOATING
C78 shared_converter_mux_0.mux_bus vss_escape 2.86922f ; **FLOATING
C79 shared_converter_mux_0.vdd vss_escape 0.95985f ; **FLOATING
C80 physical_preamp_0.iso_n vss_escape 1.04151f
C81 physical_preamp_0.iso_p vss_escape 1.04151f
.ends
