* NGSPICE file created from aimc_converter_macro_active_candidate.ext - technology: sky130A

.subckt sky130_isolated_frontend_active_load_latch_v2 out_p out_n latch_sense_p latch_sense_n
+ tail reset vdd vss eval sense_p sense_n iso_tail vdd_active
X0 latch_sense_p sense_p iso_tail vss sky130_fd_pr__nfet_01v8 ad=3.36 pd=8 as=3.12 ps=7.6 w=1.2 l=0.6
X1 out_p out_n tail vss sky130_fd_pr__nfet_01v8 ad=3.36 pd=8 as=3.12 ps=7.6 w=1.2 l=0.6
X2 out_n latch_sense_n tail vss sky130_fd_pr__nfet_01v8 ad=3.36 pd=8 as=3.12 ps=7.6 w=1.2 l=0.6
X3 out_n out_p vdd_active vdd_active sky130_fd_pr__pfet_01v8 ad=3.36 pd=8 as=3.12 ps=7.6 w=1.2 l=0.6
X4 iso_tail sense_n latch_sense_n vss sky130_fd_pr__nfet_01v8 ad=3.12 pd=7.6 as=3.36 ps=8 w=1.2 l=0.6
X5 out_n out_p tail vss sky130_fd_pr__nfet_01v8 ad=3.36 pd=8 as=3.12 ps=7.6 w=1.2 l=0.6
X6 out_n reset vdd vdd sky130_fd_pr__pfet_01v8 ad=3.36 pd=8 as=3.12 ps=7.6 w=1.2 l=0.6
X7 out_p latch_sense_p tail vss sky130_fd_pr__nfet_01v8 ad=3.36 pd=8 as=3.12 ps=7.6 w=1.2 l=0.6
X8 tail eval vss vss sky130_fd_pr__nfet_01v8 ad=16.8 pd=17.6 as=15.6 ps=17.2 w=6 l=0.6
X9 out_p out_n vdd_active vdd_active sky130_fd_pr__pfet_01v8 ad=3.36 pd=8 as=3.12 ps=7.6 w=1.2 l=0.6
X10 out_p reset vdd vdd sky130_fd_pr__pfet_01v8 ad=3.36 pd=8 as=3.12 ps=7.6 w=1.2 l=0.6
C0 latch_sense_p vdd_active 0.50449f
C1 out_n vdd 0.95698f
C2 latch_sense_n out_p 1.00043f
C3 iso_tail latch_sense_p 0.09804f
C4 out_n vdd_active 5.52673f
C5 latch_sense_n tail 0.4349f
C6 sense_p latch_sense_p 0.06485f
C7 m1_3440_12500# sense_n 0.04904f
C8 out_p reset 0.07615f
C9 eval out_p 0.04062f
C10 latch_sense_p m1_1000_12500# 0.05106f
C11 iso_tail sense_n 0.11179f
C12 iso_tail m1_3440_12500# 0.00302f
C13 out_p tail 3.33055f
C14 latch_sense_n latch_sense_p 0.0207f
C15 eval tail 0.09415f
C16 latch_sense_p out_p 0.32159f
C17 out_n latch_sense_n 1.04924f
C18 iso_tail sense_p 0.12292f
C19 latch_sense_n vdd_active 0.53393f
C20 iso_tail m1_1000_12500# 0.00302f
C21 latch_sense_n sense_n 0.05507f
C22 latch_sense_n m1_3440_12500# 0.0106f
C23 vdd out_p 1.0487f
C24 out_n out_p 1.85382f
C25 latch_sense_p tail 0.36163f
C26 iso_tail latch_sense_n 0.15122f
C27 out_p vdd_active 4.31746f
C28 vdd reset 4.28849f
C29 out_n reset 0.05967f
C30 sense_p m1_1000_12500# 0.04904f
C31 eval out_n 0.02298f
C32 out_n tail 2.28538f
C33 out_n latch_sense_p 0.27084f
C34 tail vss 27.29601f
C35 out_p vss 12.23545f
C36 latch_sense_n vss 0.71261f
C37 iso_tail vss 4.24257f
C38 vdd vss 31.12f
C39 vdd_active vss 65.63497f
C40 m1_3440_12500# vss 0.33861f ; **FLOATING
C41 m1_1000_12500# vss 0.33861f ; **FLOATING
.ends

.subckt aimc_converter_macro_active_candidate vss vdd row_drive column_sense digital_code_out
Xconverter_latch_0 converter_latch_0/out_p converter_latch_0/out_p converter_latch_0/latch_sense_p
+ converter_latch_0/latch_sense_n vss converter_latch_0/reset converter_latch_0/vdd
+ vss converter_latch_0/eval converter_latch_0/sense_p converter_latch_0/sense_n converter_latch_0/iso_tail
+ converter_latch_0/vdd_active sky130_isolated_frontend_active_load_latch_v2
C0 row_dac_10b_0/row_drive sar_readout_12b_0/vdd 0
C1 converter_latch_0/out_p sar_readout_12b_0/vdd 1.96204f
C2 row_dac_10b_0/vdd row_dac_10b_0/vss 0.78467f
C3 row_dac_10b_0/vss row_dac_10b_0/row_drive 1.08123f
C4 converter_latch_0/reset converter_latch_0/vdd -0.11975f
C5 row_dac_10b_0/vdd row_dac_10b_0/row_drive 1.10759f
C6 sar_readout_12b_0/vss row_dac_10b_0/row_drive 0.00137f
C7 converter_latch_0/out_p converter_latch_0/latch_sense_n 0.28052f
C8 converter_latch_0/reset converter_latch_0/out_p 0.16803f
C9 shared_converter_mux_0/mux_bus shared_converter_mux_0/vdd 1.55435f
C10 sar_readout_12b_0/vss converter_latch_0/out_p 1.21801f
C11 converter_latch_0/out_p converter_latch_0/latch_sense_p 0.37542f
C12 converter_latch_0/out_p converter_latch_0/vdd 1.37911f
C13 converter_latch_0/out_p row_dac_10b_0/row_drive 0.02254f
C14 converter_latch_0/eval converter_latch_0/out_p -0.00654f
C15 shared_converter_mux_0/mux_bus shared_converter_mux_0/vss 1.56464f
C16 sar_readout_12b_0/vss sar_readout_12b_0/vdd 0.53484f
C17 vdd vss 22.6565f
C18 converter_latch_0/out_p vss 16.70376f
C19 converter_latch_0/eval vss 0.05552f
C20 converter_latch_0/latch_sense_n vss 0.04747f
C21 converter_latch_0/latch_sense_p vss 0.05318f
C22 row_dac_10b_0/row_drive vss 0.96229f
C23 shared_converter_mux_0/mux_bus vss 1.22521f
C24 shared_converter_mux_0/vdd vss 0.2816f
.ends
