* NGSPICE file created from aimc_converter_macro_active_candidate_flat.ext - technology: sky130A

.subckt aimc_converter_macro_active_candidate_flat vss vdd row_drive sar_comparator_input
+ decision_p decision_n reset eval vss_escape latch_sense_p_ext latch_sense_n_ext
+ iso_tail_ext tail_ext vdd_ext
X0 physical_preamp_0.iso_tail physical_preamp_0.sense_n vdd_ext vss_escape sky130_fd_pr__nfet_01v8 ad=3.12 pd=7.6 as=3.36 ps=8 w=1.2 l=0.6
X1 vdd_ext decision_p decision_n vdd_ext sky130_fd_pr__pfet_01v8 ad=3.12 pd=7.6 as=3.36 ps=8 w=1.2 l=0.6
X2 tail_ext eval vss_escape vss_escape sky130_fd_pr__nfet_01v8 ad=16.2 pd=17.4 as=16.2 ps=17.4 w=6 l=0.6
X3 vdd_ext physical_preamp_0.sense_p physical_preamp_0.iso_tail vss_escape sky130_fd_pr__nfet_01v8 ad=3.36 pd=8 as=3.12 ps=7.6 w=1.2 l=0.6
X4 decision_p latch_sense_p_ext tail_ext vss_escape sky130_fd_pr__nfet_01v8 ad=3.36 pd=8 as=3.12 ps=7.6 w=1.2 l=0.6
X5 vdd_ext reset decision_n vdd_ext sky130_fd_pr__pfet_01v8 ad=3.12 pd=7.6 as=3.36 ps=8 w=1.2 l=0.6
X6 tail_ext latch_sense_n_ext decision_n vss_escape sky130_fd_pr__nfet_01v8 ad=3.12 pd=7.6 as=3.36 ps=8 w=1.2 l=0.6
X7 decision_p decision_n vdd_ext vdd_ext sky130_fd_pr__pfet_01v8 ad=3.36 pd=8 as=3.12 ps=7.6 w=1.2 l=0.6
X8 tail_ext decision_p decision_n vss_escape sky130_fd_pr__nfet_01v8 ad=3.12 pd=7.6 as=3.36 ps=8 w=1.2 l=0.6
X9 latch_sense_p_ext row_drive iso_tail_ext vss_escape sky130_fd_pr__nfet_01v8 ad=3.36 pd=8 as=3.12 ps=7.6 w=1.2 l=0.6
X10 iso_tail_ext sar_comparator_input latch_sense_n_ext vss_escape sky130_fd_pr__nfet_01v8 ad=3.12 pd=7.6 as=3.36 ps=8 w=1.2 l=0.6
X11 decision_p reset vdd_ext vdd_ext sky130_fd_pr__pfet_01v8 ad=3.36 pd=8 as=3.12 ps=7.6 w=1.2 l=0.6
X12 decision_p decision_n tail_ext vss_escape sky130_fd_pr__nfet_01v8 ad=3.36 pd=8 as=3.12 ps=7.6 w=1.2 l=0.6
C0 vdd_ext iso_tail_ext 0.86179f
C1 decision_p decision_n 2.54301f
C2 sar_readout_12b_0.vdd row_drive 0.58157f
C3 row_dac_10b_0.vdd row_drive 1.11462f
C4 sar_comparator_input vdd_ext 1.11374f
C5 physical_preamp_0.sense_p row_drive 0.19241f
C6 physical_preamp_0.sense_n vdd_ext 0.05679f
C7 sar_readout_12b_0.vss vdd_ext 0.93663f
C8 shared_converter_mux_0.vdd shared_converter_mux_0.mux_bus 1.55306f
C9 shared_converter_mux_0.vss shared_converter_mux_0.mux_bus 1.56188f
C10 vss latch_sense_p_ext 0.23329f
C11 li_67560_3080# row_drive 2.7609f
C12 tail_ext vdd_ext 1.9856f
C13 reset vdd_ext 4.48789f
C14 shared_converter_mux_0.mux_bus vss 0.03132f
C15 shared_converter_mux_0.vdd row_drive 0.00246f
C16 row_drive latch_sense_n_ext 0.57746f
C17 shared_converter_mux_0.vss row_drive 0.00246f
C18 sar_comparator_input iso_tail_ext 0.16721f
C19 m2_64900_1400# row_drive 0.01663f
C20 vss row_drive 0.22445f
C21 sar_readout_12b_0.vss iso_tail_ext 0.60045f
C22 physical_preamp_0.iso_tail row_drive 0.38216f
C23 physical_preamp_0.sense_p li_67560_3080# 0
C24 physical_preamp_0.sense_n sar_comparator_input 0.07548f
C25 vdd_ext latch_sense_p_ext 3.43095f
C26 latch_sense_n_ext decision_n 0.18428f
C27 shared_converter_mux_0.mux_bus vdd_ext 0.00217f
C28 physical_preamp_0.sense_p m2_64900_1400# 0.03788f
C29 decision_p vdd_ext 3.8282f
C30 physical_preamp_0.sense_p physical_preamp_0.iso_tail 0.13895f
C31 vdd_ext row_drive 4.1744f
C32 reset tail_ext 0.17577f
C33 li_67560_3080# m2_64900_1400# 0
C34 iso_tail_ext latch_sense_p_ext 0.12577f
C35 li_67560_3080# physical_preamp_0.iso_tail 0.00653f
C36 shared_converter_mux_0.vdd vss 0.2816f
C37 vss latch_sense_n_ext 0.23329f
C38 sar_readout_12b_0.vdd vdd_ext 1.39936f
C39 vdd_ext decision_n 3.9382f
C40 physical_preamp_0.sense_p vdd_ext 0.07662f
C41 iso_tail_ext row_drive 2.39704f
C42 m2_64900_1400# physical_preamp_0.iso_tail 0.34303f
C43 eval vdd_ext 0
C44 tail_ext latch_sense_p_ext 0.0334f
C45 sar_comparator_input row_drive 5.24644f
C46 li_67560_3080# vdd_ext 0.56522f
C47 physical_preamp_0.sense_n row_drive 0.09115f
C48 sar_readout_12b_0.vss row_drive 0.29433f
C49 sar_readout_12b_0.vdd iso_tail_ext 0.27521f
C50 tail_ext decision_p 0.48065f
C51 shared_converter_mux_0.vdd vdd_ext 0
C52 reset decision_p 0.376f
C53 vdd_ext latch_sense_n_ext 3.48444f
C54 shared_converter_mux_0.vss vdd_ext 0
C55 m2_64900_1400# vdd_ext 0.94428f
C56 vdd_ext vss 0.21361f
C57 physical_preamp_0.sense_p sar_comparator_input 0.04049f
C58 physical_preamp_0.iso_tail vdd_ext 0.49541f
C59 sar_readout_12b_0.vdd sar_readout_12b_0.vss 0.49712f
C60 row_dac_10b_0.vss row_drive 1.08123f
C61 tail_ext decision_n 0.48065f
C62 reset decision_n 0.31048f
C63 iso_tail_ext latch_sense_n_ext 0.12577f
C64 decision_p latch_sense_p_ext 0.18428f
C65 tail_ext eval 0.36751f
C66 row_drive latch_sense_p_ext 0.6214f
C67 vdd row_drive 0.1964f
C68 li_67560_3080# physical_preamp_0.sense_n 0.10132f
C69 sar_comparator_input latch_sense_n_ext 0.04279f
C70 shared_converter_mux_0.mux_bus row_drive 0.06281f
C71 m2_64900_1400# sar_comparator_input 0.1759f
C72 row_dac_10b_0.vdd row_dac_10b_0.vss 0.78467f
C73 physical_preamp_0.iso_tail sar_comparator_input 0.03759f
C74 m2_64900_1400# physical_preamp_0.sense_n 0.04189f
C75 tail_ext latch_sense_n_ext 0.0334f
C76 physical_preamp_0.sense_n physical_preamp_0.iso_tail 0.12781f
C77 vss vss_escape 36.2211f
C78 vdd vss_escape 36.7f
C79 iso_tail_ext vss_escape 66.3001f
C80 latch_sense_n_ext vss_escape 8.9128f
C81 latch_sense_p_ext vss_escape 36.4191f
C82 decision_p vss_escape 7.38983f
C83 tail_ext vss_escape 81.08725f
C84 vdd_ext vss_escape 0.26184p
C85 m2_64900_1400# vss_escape 0.67354f ; **FLOATING
C86 sar_readout_12b_0.vss vss_escape 1.33686f ; **FLOATING
C87 row_dac_10b_0.vss vss_escape 1.40333f ; **FLOATING
C88 row_dac_10b_0.vdd vss_escape 1.33457f ; **FLOATING
C89 sar_readout_12b_0.vdd vss_escape 1.77614f ; **FLOATING
C90 shared_converter_mux_0.vss vss_escape 1.39454f ; **FLOATING
C91 shared_converter_mux_0.mux_bus vss_escape 2.86922f ; **FLOATING
C92 shared_converter_mux_0.vdd vss_escape 0.95985f ; **FLOATING
C93 li_67560_3080# vss_escape 8.17525f ; **FLOATING
C94 physical_preamp_0.iso_tail vss_escape 4.29677f
.ends
