* NGSPICE file created from aimc_converter_macro_active_candidate_flat.ext - technology: sky130A

.subckt aimc_converter_macro_active_candidate_flat vss vdd row_drive sar_comparator_input
+ decision_p decision_n reset eval vss_escape latch_sense_p_ext latch_sense_n_ext
+ iso_tail_ext tail_ext vdd_ext
X0 physical_preamp_0.iso_tail physical_preamp_0.sense_n physical_preamp_0.iso_n vss_escape sky130_fd_pr__nfet_01v8 ad=3.12 pd=7.6 as=3.36 ps=8 w=1.2 l=0.6
X1 vdd_ext decision_p decision_n vdd_ext sky130_fd_pr__pfet_01v8 ad=3.12 pd=7.6 as=3.36 ps=8 w=1.2 l=0.6
X2 tail_ext eval vss_escape vss_escape sky130_fd_pr__nfet_01v8 ad=16.2 pd=17.4 as=16.2 ps=17.4 w=6 l=0.6
X3 vdd_ext physical_preamp_0.sense_p physical_preamp_0.iso_tail vss_escape sky130_fd_pr__nfet_01v8 ad=3.36 pd=8 as=3.12 ps=7.6 w=1.2 l=0.6
X4 decision_p latch_sense_p_ext tail_ext vss_escape sky130_fd_pr__nfet_01v8 ad=3.36 pd=8 as=3.12 ps=7.6 w=1.2 l=0.6
X5 vdd_ext reset decision_n vdd_ext sky130_fd_pr__pfet_01v8 ad=3.12 pd=7.6 as=3.36 ps=8 w=1.2 l=0.6
X6 tail_ext latch_sense_n_ext decision_n vss_escape sky130_fd_pr__nfet_01v8 ad=3.12 pd=7.6 as=3.36 ps=8 w=1.2 l=0.6
X7 decision_p decision_n vdd_ext vdd_ext sky130_fd_pr__pfet_01v8 ad=3.36 pd=8 as=3.12 ps=7.6 w=1.2 l=0.6
X8 tail_ext decision_p decision_n vss_escape sky130_fd_pr__nfet_01v8 ad=3.12 pd=7.6 as=3.36 ps=8 w=1.2 l=0.6
X9 latch_sense_p_ext row_drive iso_tail_ext vss_escape sky130_fd_pr__nfet_01v8 ad=3.36 pd=8 as=3.12 ps=7.6 w=1.2 l=0.6
X10 iso_tail_ext sar_comparator_input latch_sense_n_ext vss_escape sky130_fd_pr__nfet_01v8 ad=3.12 pd=7.6 as=3.36 ps=8 w=1.2 l=0.6
X11 decision_p reset vdd_ext vdd_ext sky130_fd_pr__pfet_01v8 ad=3.36 pd=8 as=3.12 ps=7.6 w=1.2 l=0.6
X12 decision_p decision_n tail_ext vss_escape sky130_fd_pr__nfet_01v8 ad=3.36 pd=8 as=3.12 ps=7.6 w=1.2 l=0.6
C0 physical_preamp_0.iso_tail sar_comparator_input 0.03759f
C1 tail_ext decision_n 0.48065f
C2 li_67560_3080# physical_preamp_0.iso_tail 0.00653f
C3 latch_sense_n_ext row_drive 0.57746f
C4 iso_tail_ext latch_sense_p_ext 0.12577f
C5 physical_preamp_0.sense_n row_drive 0.09115f
C6 row_dac_10b_0.vdd row_drive 1.11462f
C7 vdd_ext row_drive 4.17046f
C8 shared_converter_mux_0.mux_bus shared_converter_mux_0.vdd 1.55306f
C9 decision_n reset 0.31048f
C10 sar_readout_12b_0.vss row_drive 0.29433f
C11 sar_comparator_input m2_64900_1400# 0.1759f
C12 vdd_ext latch_sense_n_ext 3.48444f
C13 li_67560_3080# m2_64900_1400# 0
C14 vdd_ext physical_preamp_0.sense_n 0.02073f
C15 sar_readout_12b_0.vdd row_drive 0.58157f
C16 vss row_drive 0.22445f
C17 physical_preamp_0.sense_p physical_preamp_0.iso_tail 0.13895f
C18 eval vdd_ext 0
C19 vss latch_sense_n_ext 0.23329f
C20 vdd_ext sar_readout_12b_0.vss 0.93663f
C21 sar_comparator_input row_drive 5.24644f
C22 li_67560_3080# row_drive 2.7609f
C23 vdd_ext sar_readout_12b_0.vdd 1.39936f
C24 sar_comparator_input latch_sense_n_ext 0.04279f
C25 physical_preamp_0.iso_n physical_preamp_0.iso_tail 0.05314f
C26 vdd_ext vss 0.21361f
C27 sar_readout_12b_0.vdd sar_readout_12b_0.vss 0.49712f
C28 physical_preamp_0.sense_p m2_64900_1400# 0.03788f
C29 row_drive latch_sense_p_ext 0.6214f
C30 physical_preamp_0.sense_n sar_comparator_input 0.07548f
C31 li_67560_3080# physical_preamp_0.sense_n 0.10132f
C32 vdd_ext decision_p 3.8282f
C33 tail_ext latch_sense_n_ext 0.0334f
C34 vdd_ext sar_comparator_input 1.08524f
C35 vdd_ext li_67560_3080# 0.56514f
C36 shared_converter_mux_0.mux_bus row_drive 0.06281f
C37 vdd_ext tail_ext 1.9856f
C38 physical_preamp_0.iso_n m2_64900_1400# 0.41846f
C39 shared_converter_mux_0.vss row_drive 0.00246f
C40 vdd_ext latch_sense_p_ext 3.43095f
C41 eval tail_ext 0.36751f
C42 physical_preamp_0.sense_p row_drive 0.19241f
C43 physical_preamp_0.iso_tail m2_64900_1400# 0.34303f
C44 vss latch_sense_p_ext 0.23329f
C45 vdd_ext shared_converter_mux_0.mux_bus 0.00217f
C46 vdd_ext reset 4.48789f
C47 shared_converter_mux_0.vss vdd_ext 0
C48 physical_preamp_0.iso_n row_drive 0.00394f
C49 physical_preamp_0.sense_p vdd_ext 0.07662f
C50 shared_converter_mux_0.vdd row_drive 0.00246f
C51 tail_ext decision_p 0.48065f
C52 latch_sense_p_ext decision_p 0.18428f
C53 row_dac_10b_0.vss row_drive 1.08123f
C54 latch_sense_n_ext decision_n 0.18428f
C55 row_drive iso_tail_ext 2.39704f
C56 physical_preamp_0.iso_tail row_drive 0.38216f
C57 shared_converter_mux_0.mux_bus vss 0.03132f
C58 physical_preamp_0.iso_n physical_preamp_0.sense_n 0.02157f
C59 latch_sense_n_ext iso_tail_ext 0.12577f
C60 tail_ext latch_sense_p_ext 0.0334f
C61 row_dac_10b_0.vss row_dac_10b_0.vdd 0.78467f
C62 physical_preamp_0.iso_n vdd_ext 0.04107f
C63 vdd_ext shared_converter_mux_0.vdd 0
C64 vdd_ext decision_n 3.9382f
C65 decision_p reset 0.376f
C66 physical_preamp_0.sense_n physical_preamp_0.iso_tail 0.12781f
C67 physical_preamp_0.sense_p sar_comparator_input 0.04049f
C68 vdd_ext iso_tail_ext 0.86179f
C69 physical_preamp_0.sense_p li_67560_3080# 0
C70 vdd_ext physical_preamp_0.iso_tail 0.42851f
C71 sar_readout_12b_0.vss iso_tail_ext 0.60045f
C72 m2_64900_1400# row_drive 0.01663f
C73 tail_ext reset 0.17577f
C74 shared_converter_mux_0.vdd vss 0.2816f
C75 sar_readout_12b_0.vdd iso_tail_ext 0.27521f
C76 decision_n decision_p 2.54301f
C77 physical_preamp_0.iso_n sar_comparator_input 0.0285f
C78 physical_preamp_0.sense_n m2_64900_1400# 0.04189f
C79 physical_preamp_0.iso_n li_67560_3080# 0
C80 vdd row_drive 0.1964f
C81 vdd_ext m2_64900_1400# 0.51058f
C82 sar_comparator_input iso_tail_ext 0.16721f
C83 shared_converter_mux_0.vss shared_converter_mux_0.mux_bus 1.56188f
C84 vss vss_escape 36.2211f
C85 vdd vss_escape 36.7f
C86 iso_tail_ext vss_escape 66.3001f
C87 latch_sense_n_ext vss_escape 8.9128f
C88 latch_sense_p_ext vss_escape 36.4191f
C89 decision_p vss_escape 7.38983f
C90 tail_ext vss_escape 81.08725f
C91 vdd_ext vss_escape 0.26035p
C92 m2_64900_1400# vss_escape 0.68223f ; **FLOATING
C93 sar_readout_12b_0.vss vss_escape 1.33686f ; **FLOATING
C94 row_dac_10b_0.vss vss_escape 1.40333f ; **FLOATING
C95 row_dac_10b_0.vdd vss_escape 1.33457f ; **FLOATING
C96 sar_readout_12b_0.vdd vss_escape 1.77614f ; **FLOATING
C97 shared_converter_mux_0.vss vss_escape 1.39454f ; **FLOATING
C98 shared_converter_mux_0.mux_bus vss_escape 2.86922f ; **FLOATING
C99 shared_converter_mux_0.vdd vss_escape 0.95985f ; **FLOATING
C100 li_67560_3080# vss_escape 8.17525f ; **FLOATING
C101 physical_preamp_0.iso_n vss_escape 1.39269f
C102 physical_preamp_0.iso_tail vss_escape 4.32641f
.ends
