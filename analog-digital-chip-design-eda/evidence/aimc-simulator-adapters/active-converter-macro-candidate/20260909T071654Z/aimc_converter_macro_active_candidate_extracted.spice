* NGSPICE file created from aimc_converter_macro_active_candidate.ext - technology: sky130A

.subckt sky130_transistor_active_isolation_pair iso_tail iso_p iso_n sense_p sense_n
+ m1_3440_500# m1_1000_500# m2_900_1400# VSUBS
X0 iso_tail sense_n iso_n VSUBS sky130_fd_pr__nfet_01v8 ad=3.12 pd=7.6 as=3.36 ps=8 w=1.2 l=0.6
X1 iso_p sense_p iso_tail VSUBS sky130_fd_pr__nfet_01v8 ad=3.36 pd=8 as=3.12 ps=7.6 w=1.2 l=0.6
C0 sense_p m2_900_1400# 0.04273f
C1 sense_p m1_1000_500# 0.04555f
C2 iso_n iso_tail 0.05717f
C3 sense_p iso_p 0.02157f
C4 iso_n m2_900_1400# 0.41846f
C5 iso_n sense_n 0.02157f
C6 m2_900_1400# iso_tail 0.34398f
C7 sense_n iso_tail 0.11179f
C8 sense_n m2_900_1400# 0.04273f
C9 m1_3440_500# iso_n 0.0015f
C10 iso_p iso_n 0.00782f
C11 m1_1000_500# iso_tail 0.0015f
C12 m1_3440_500# iso_tail 0.0015f
C13 iso_p iso_tail 0.05749f
C14 m2_900_1400# m1_1000_500# 0.01113f
C15 m1_3440_500# m2_900_1400# 0.01113f
C16 iso_p m2_900_1400# 0.41846f
C17 m1_3440_500# sense_n 0.04555f
C18 sense_p iso_tail 0.12292f
C19 iso_p m1_1000_500# 0.0015f
C20 iso_n VSUBS 1.04634f
C21 iso_p VSUBS 1.04634f
C22 iso_tail VSUBS 4.24257f
C23 m2_900_1400# VSUBS 1.01648f
C24 m1_3440_500# VSUBS 0.31893f
C25 m1_1000_500# VSUBS 0.31893f
.ends

.subckt escaped_input_latch out_p out_n latch_sense_p latch_sense_n tail reset vdd
+ vss eval sense_p sense_n iso_tail vdd_active
X0 out_p out_n vdd_active vdd_active sky130_fd_pr__pfet_01v8 ad=3.36 pd=8 as=3.12 ps=7.6 w=1.2 l=0.6
X1 vdd reset out_n vdd sky130_fd_pr__pfet_01v8 ad=3.12 pd=7.6 as=3.36 ps=8 w=1.2 l=0.6
X2 tail out_p out_n vss sky130_fd_pr__nfet_01v8 ad=3.12 pd=7.6 as=3.36 ps=8 w=1.2 l=0.6
X3 out_p reset vdd vdd sky130_fd_pr__pfet_01v8 ad=3.36 pd=8 as=3.12 ps=7.6 w=1.2 l=0.6
X4 out_p out_n tail vss sky130_fd_pr__nfet_01v8 ad=3.36 pd=8 as=3.12 ps=7.6 w=1.2 l=0.6
X5 tail latch_sense_n out_n vss sky130_fd_pr__nfet_01v8 ad=3.12 pd=7.6 as=3.36 ps=8 w=1.2 l=0.6
X6 tail eval vss vss sky130_fd_pr__nfet_01v8 ad=16.2 pd=17.4 as=16.2 ps=17.4 w=6 l=0.6
X7 out_p latch_sense_p tail vss sky130_fd_pr__nfet_01v8 ad=3.36 pd=8 as=3.12 ps=7.6 w=1.2 l=0.6
X8 iso_tail sense_n latch_sense_n vss sky130_fd_pr__nfet_01v8 ad=3.12 pd=7.6 as=3.36 ps=8 w=1.2 l=0.6
X9 vdd_active out_p out_n vdd_active sky130_fd_pr__pfet_01v8 ad=3.12 pd=7.6 as=3.36 ps=8 w=1.2 l=0.6
X10 latch_sense_p sense_p iso_tail vss sky130_fd_pr__nfet_01v8 ad=3.36 pd=8 as=3.12 ps=7.6 w=1.2 l=0.6
C0 iso_tail latch_sense_n 0.20888f
C1 vdd_active out_n 3.16716f
C2 latch_sense_p iso_tail 0.20888f
C3 sense_n latch_sense_n 0.22977f
C4 out_p tail 0.46979f
C5 sense_p latch_sense_p 0.22977f
C6 out_p vdd 0.76206f
C7 vdd tail 0.9918f
C8 eval tail 0.35666f
C9 sense_n iso_tail 0.10725f
C10 sense_p iso_tail 0.26105f
C11 out_p out_n 2.54301f
C12 reset out_p 0.376f
C13 out_p latch_sense_p 0.18428f
C14 out_n tail 0.46979f
C15 tail latch_sense_n 0.0334f
C16 reset tail 0.16491f
C17 vdd out_n 0.77104f
C18 latch_sense_p tail 0.0334f
C19 reset vdd 4.47121f
C20 vdd_active out_p 3.06556f
C21 out_n latch_sense_n 0.18428f
C22 vdd_active tail 0.9938f
C23 reset out_n 0.31048f
C24 iso_tail vss 29.23796f
C25 latch_sense_n vss 1.7693f
C26 latch_sense_p vss 1.56796f
C27 out_n vss 13.58747f
C28 tail vss 89.03816f
C29 vdd_active vss 90.11912f
C30 vdd vss 78.65506f
.ends

.subckt aimc_converter_macro_active_candidate vss vdd row_drive sar_comparator_input
+ decision_p decision_n reset eval vss_escape latch_sense_p_ext iso_tail_ext tail_ext
+ vdd_ext preamp_iso_tail_ext
Xphysical_preamp_0 physical_preamp_0/iso_tail physical_preamp_0/iso_p physical_preamp_0/iso_n
+ physical_preamp_0/sense_p physical_preamp_0/sense_n sar_comparator_input row_drive
+ physical_preamp_0/m2_900_1400# vss_escape sky130_transistor_active_isolation_pair
Xconverter_latch_0 decision_p decision_n latch_sense_p_ext latch_sense_p_ext tail_ext
+ reset vdd_ext vss_escape eval row_drive sar_comparator_input iso_tail_ext vdd_ext
+ escaped_input_latch
C0 shared_converter_mux_0/mux_bus shared_converter_mux_0/vss 1.56188f
C1 row_drive shared_converter_mux_0/vss 0.00246f
C2 sar_readout_12b_0/vss row_drive 0.29422f
C3 vss vdd_ext 0.19458f
C4 row_drive shared_converter_mux_0/mux_bus 0.06281f
C5 vss latch_sense_p_ext 1.61192f
C6 physical_preamp_0/iso_p sar_comparator_input 0.02717f
C7 physical_preamp_0/sense_p sar_comparator_input 0.04049f
C8 physical_preamp_0/iso_tail m1_67140_3540# 0.00394f
C9 tail_ext decision_p 0.01085f
C10 physical_preamp_0/iso_n physical_preamp_0/m2_900_1400# -0
C11 shared_converter_mux_0/vdd vdd_ext 0
C12 physical_preamp_0/iso_tail row_drive 0.02329f
C13 tail_ext reset 0.01085f
C14 m1_67140_3540# latch_sense_p_ext 0.02746f
C15 vdd_ext shared_converter_mux_0/vss 0
C16 sar_readout_12b_0/vss vdd_ext 0.93663f
C17 shared_converter_mux_0/mux_bus vdd_ext 0.00217f
C18 row_dac_10b_0/vss row_dac_10b_0/vdd 0.78467f
C19 row_drive vdd_ext 2.1538f
C20 row_drive latch_sense_p_ext 0.44552f
C21 vdd row_drive 0.1964f
C22 sar_readout_12b_0/vss sar_readout_12b_0/vdd 0.49712f
C23 eval vdd_ext 0
C24 row_drive sar_readout_12b_0/vdd 0.57218f
C25 physical_preamp_0/iso_p physical_preamp_0/m2_900_1400# 0
C26 physical_preamp_0/sense_p physical_preamp_0/m2_900_1400# -0.00637f
C27 physical_preamp_0/iso_tail latch_sense_p_ext 0.01386f
C28 sar_comparator_input physical_preamp_0/m2_900_1400# 0.16477f
C29 sar_readout_12b_0/vss iso_tail_ext 0.60045f
C30 row_drive iso_tail_ext 1.71857f
C31 latch_sense_p_ext vdd_ext 0.33498f
C32 decision_p vdd_ext 0
C33 sar_readout_12b_0/vdd vdd_ext 1.39936f
C34 reset vdd_ext 0.01669f
C35 row_drive row_dac_10b_0/vss 1.08123f
C36 physical_preamp_0/iso_p row_drive -0
C37 physical_preamp_0/sense_p row_drive 0.03836f
C38 iso_tail_ext vdd_ext 0.3078f
C39 latch_sense_p_ext iso_tail_ext 0.00637f
C40 sar_comparator_input row_drive 5.23145f
C41 sar_comparator_input physical_preamp_0/sense_n 0.02993f
C42 iso_tail_ext sar_readout_12b_0/vdd 0.27521f
C43 physical_preamp_0/iso_tail sar_comparator_input 0.0361f
C44 physical_preamp_0/sense_p latch_sense_p_ext 0.00135f
C45 sar_comparator_input vdd_ext 0.06859f
C46 sar_comparator_input latch_sense_p_ext 0.00226f
C47 row_drive row_dac_10b_0/vdd 1.11462f
C48 vss shared_converter_mux_0/vdd 0.2816f
C49 vss m1_67140_3540# 0.00304f
C50 row_drive physical_preamp_0/m2_900_1400# -0.00731f
C51 physical_preamp_0/sense_n physical_preamp_0/m2_900_1400# -0.00318f
C52 vss shared_converter_mux_0/mux_bus 0.03132f
C53 vss row_drive 0.22445f
C54 sar_comparator_input physical_preamp_0/iso_n 0.027f
C55 m1_69940_2940# preamp_iso_tail_ext 0.03103f
C56 sar_comparator_input iso_tail_ext 0.05996f
C57 eval tail_ext 0.01085f
C58 decision_n tail_ext 0.01085f
C59 shared_converter_mux_0/vdd shared_converter_mux_0/mux_bus 1.55306f
C60 row_drive shared_converter_mux_0/vdd 0.00246f
C61 preamp_iso_tail_ext vss_escape 0.18641f
C62 vss vss_escape 36.6898f
C63 vdd vss_escape 36.7f
C64 m1_69940_2940# vss_escape 0.19727f ; **FLOATING
C65 m1_67140_3540# vss_escape 0.32849f ; **FLOATING
C66 iso_tail_ext vss_escape -1.05232f
C67 sar_comparator_input vss_escape 10.66696f
C68 latch_sense_p_ext vss_escape 13.2832f
C69 decision_n vss_escape 3.8093f
C70 eval vss_escape 0.78348f
C71 row_drive vss_escape 19.1176f
C72 vdd_ext vss_escape 34.08534f
.ends
