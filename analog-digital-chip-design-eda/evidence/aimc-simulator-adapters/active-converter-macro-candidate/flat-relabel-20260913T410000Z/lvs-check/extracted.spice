* NGSPICE file created from aimc_converter_macro_active_candidate.ext - technology: sky130A

.subckt aimc_converter_macro_active_candidate vss vdd row_drive sar_comparator_input
+ decision_p decision_n reset eval vss_escape latch_sense_p_ext latch_sense_n_ext
+ iso_tail_ext tail_ext vdd_ext
X0 preamp_iso_tail_ext sar_comparator_input latch_sense_n_ext_uq0 vss_escape sky130_fd_pr__nfet_01v8 ad=3.12 pd=7.6 as=3.36 ps=8 w=1.2 l=0.6
X1 vdd_ext decision_p decision_n vdd_ext sky130_fd_pr__pfet_01v8 ad=3.12 pd=7.6 as=3.36 ps=8 w=1.2 l=0.6
X2 tail_ext eval vss_escape vss_escape sky130_fd_pr__nfet_01v8 ad=16.2 pd=17.4 as=16.2 ps=17.4 w=6 l=0.6
X3 latch_sense_p_ext_uq0 row_drive preamp_iso_tail_ext vss_escape sky130_fd_pr__nfet_01v8 ad=3.36 pd=8 as=3.12 ps=7.6 w=1.2 l=0.6
X4 decision_p latch_sense_p_ext tail_ext vss_escape sky130_fd_pr__nfet_01v8 ad=3.36 pd=8 as=3.12 ps=7.6 w=1.2 l=0.6
X5 vdd_ext reset decision_n vdd_ext sky130_fd_pr__pfet_01v8 ad=3.12 pd=7.6 as=3.36 ps=8 w=1.2 l=0.6
X6 tail_ext latch_sense_n_ext decision_n vss_escape sky130_fd_pr__nfet_01v8 ad=3.12 pd=7.6 as=3.36 ps=8 w=1.2 l=0.6
X7 decision_p decision_n vdd_ext vdd_ext sky130_fd_pr__pfet_01v8 ad=3.36 pd=8 as=3.12 ps=7.6 w=1.2 l=0.6
X8 tail_ext decision_p decision_n vss_escape sky130_fd_pr__nfet_01v8 ad=3.12 pd=7.6 as=3.36 ps=8 w=1.2 l=0.6
X9 latch_sense_p_ext row_drive iso_tail_ext vss_escape sky130_fd_pr__nfet_01v8 ad=3.36 pd=8 as=3.12 ps=7.6 w=1.2 l=0.6
X10 iso_tail_ext sar_comparator_input latch_sense_n_ext vss_escape sky130_fd_pr__nfet_01v8 ad=3.12 pd=7.6 as=3.36 ps=8 w=1.2 l=0.6
X11 decision_p reset vdd_ext vdd_ext sky130_fd_pr__pfet_01v8 ad=3.36 pd=8 as=3.12 ps=7.6 w=1.2 l=0.6
X12 decision_p decision_n tail_ext vss_escape sky130_fd_pr__nfet_01v8 ad=3.36 pd=8 as=3.12 ps=7.6 w=1.2 l=0.6
C0 latch_sense_p_ext_uq0 m1_65180_1400# 0.06921f
C1 latch_sense_n_ext_uq0 m2_64900_1400# 0.48274f
C2 latch_sense_p_ext_uq0 sar_comparator_input 0.02717f
C3 latch_sense_n_ext_uq0 preamp_iso_tail_ext 0.14951f
C4 row_dac_10b_0.vdd row_drive 1.11462f
C5 row_drive latch_sense_p_ext 1.13418f
C6 row_dac_10b_0.vss row_drive 1.08123f
C7 shared_converter_mux_0.vdd vdd_ext 0
C8 iso_tail_ext vdd_ext 0.3078f
C9 preamp_iso_tail_ext m2_64900_1400# 0.33864f
C10 shared_converter_mux_0.vss row_drive 0.00246f
C11 sar_readout_12b_0.vss iso_tail_ext 0.60045f
C12 decision_p reset 0.376f
C13 latch_sense_n_ext_uq0 vss 0.00437f
C14 reset vdd_ext 4.48789f
C15 latch_sense_n_ext_uq0 m1_65180_1400# 0
C16 m1_68300_3080# row_drive 3.72253f
C17 decision_p vdd_ext 3.8282f
C18 sar_readout_12b_0.vdd row_drive 0.58157f
C19 shared_converter_mux_0.vdd vss 0.2816f
C20 shared_converter_mux_0.mux_bus shared_converter_mux_0.vdd 1.55306f
C21 iso_tail_ext latch_sense_n_ext 0.21209f
C22 latch_sense_n_ext_uq0 sar_comparator_input 0.16338f
C23 latch_sense_p_ext_uq0 m1_68300_3080# 0
C24 sar_readout_12b_0.vss vdd_ext 0.93663f
C25 latch_sense_p_ext_uq0 row_drive 0.03151f
C26 tail_ext eval 0.36751f
C27 m1_65180_1400# m2_64900_1400# 0.13847f
C28 iso_tail_ext sar_comparator_input 0.16721f
C29 vss vdd_ext 0.19458f
C30 preamp_iso_tail_ext m1_65180_1400# 0.14439f
C31 shared_converter_mux_0.mux_bus vdd_ext 0.00217f
C32 m2_64900_1400# sar_comparator_input 0.25407f
C33 reset decision_n 0.31048f
C34 decision_p decision_n 2.54301f
C35 decision_n vdd_ext 3.9382f
C36 preamp_iso_tail_ext sar_comparator_input 0.21886f
C37 iso_tail_ext latch_sense_p_ext 0.21294f
C38 vdd_ext sar_comparator_input 0.06859f
C39 vss latch_sense_n_ext 0.23985f
C40 shared_converter_mux_0.mux_bus vss 0.03132f
C41 latch_sense_n_ext_uq0 m1_68300_3080# 0.13081f
C42 m1_65180_1400# vss 0.00102f
C43 latch_sense_n_ext_uq0 row_drive 0.18101f
C44 decision_p latch_sense_p_ext 0.18428f
C45 vdd row_drive 0.1964f
C46 shared_converter_mux_0.vdd row_drive 0.00246f
C47 decision_n latch_sense_n_ext 0.18428f
C48 reset tail_ext 0.17577f
C49 sar_comparator_input latch_sense_n_ext 0.23009f
C50 decision_p tail_ext 0.48065f
C51 vss sar_comparator_input 0.05708f
C52 iso_tail_ext row_drive 2.39704f
C53 sar_readout_12b_0.vdd iso_tail_ext 0.27521f
C54 tail_ext vdd_ext 1.9856f
C55 m1_65180_1400# sar_comparator_input 0.00413f
C56 latch_sense_p_ext_uq0 latch_sense_n_ext_uq0 0.00824f
C57 m1_68300_3080# m2_64900_1400# 0
C58 m2_64900_1400# row_drive 0.0739f
C59 shared_converter_mux_0.vss vdd_ext 0
C60 m1_68300_3080# preamp_iso_tail_ext 0.01748f
C61 m1_68300_3080# vdd_ext 0.15428f
C62 vss latch_sense_p_ext 0.23483f
C63 preamp_iso_tail_ext row_drive 0.41874f
C64 sar_readout_12b_0.vdd vdd_ext 1.39936f
C65 vdd_ext row_drive 2.91195f
C66 latch_sense_p_ext_uq0 m2_64900_1400# 0.4047f
C67 tail_ext latch_sense_n_ext 0.0334f
C68 sar_readout_12b_0.vss row_drive 0.29433f
C69 sar_readout_12b_0.vdd sar_readout_12b_0.vss 0.49712f
C70 latch_sense_p_ext_uq0 preamp_iso_tail_ext 0.03291f
C71 decision_n tail_ext 0.48065f
C72 shared_converter_mux_0.mux_bus shared_converter_mux_0.vss 1.56188f
C73 row_drive latch_sense_n_ext 1.06835f
C74 vss row_drive 1.35968f
C75 m1_68300_3080# m1_65180_1400# 0.12858f
C76 shared_converter_mux_0.mux_bus row_drive 0.06281f
C77 m1_65180_1400# row_drive 0.71321f
C78 row_dac_10b_0.vss row_dac_10b_0.vdd 0.78467f
C79 vdd_ext eval 0
C80 m1_68300_3080# sar_comparator_input 0.07262f
C81 sar_comparator_input row_drive 5.42913f
C82 tail_ext latch_sense_p_ext 0.0334f
C83 vss vss_escape 36.2292f
C84 vdd vss_escape 36.7f
C85 iso_tail_ext vss_escape 20.9682f
C86 decision_p vss_escape 7.71981f
C87 tail_ext vss_escape 83.89029f
C88 vdd_ext vss_escape 0.23925p
C89 m2_64900_1400# vss_escape 0.6881f ; **FLOATING
C90 sar_readout_12b_0.vss vss_escape 1.33686f ; **FLOATING
C91 row_dac_10b_0.vss vss_escape 1.40333f ; **FLOATING
C92 row_dac_10b_0.vdd vss_escape 1.33457f ; **FLOATING
C93 sar_readout_12b_0.vdd vss_escape 1.77614f ; **FLOATING
C94 m1_65180_1400# vss_escape 0.93143f ; **FLOATING
C95 m1_68300_3080# vss_escape 7.90194f ; **FLOATING
C96 shared_converter_mux_0.vss vss_escape 1.39454f ; **FLOATING
C97 shared_converter_mux_0.mux_bus vss_escape 2.86922f ; **FLOATING
C98 shared_converter_mux_0.vdd vss_escape 0.95985f ; **FLOATING
C99 latch_sense_n_ext_uq0 vss_escape 25.62962f
C100 latch_sense_p_ext_uq0 vss_escape 70.98233f
C101 preamp_iso_tail_ext vss_escape 97.35442f
.ends
