* NGSPICE file created from aimc_converter_macro_active_candidate_flat.ext - technology: sky130A

.subckt aimc_converter_macro_active_candidate_flat vss vdd row_drive sar_comparator_input
+ decision_p decision_n reset eval vss_escape latch_sense_p_ext iso_tail_ext tail_ext
+ vdd_ext preamp_iso_tail_ext
X0 preamp_iso_tail_ext sar_comparator_input vdd_ext vss_escape sky130_fd_pr__nfet_01v8 ad=3.12 pd=7.6 as=3.36 ps=8 w=1.2 l=0.6
X1 vdd_ext decision_p decision_n vdd_ext sky130_fd_pr__pfet_01v8 ad=3.12 pd=7.6 as=3.36 ps=8 w=1.2 l=0.6
X2 tail_ext eval vss_escape vss_escape sky130_fd_pr__nfet_01v8 ad=16.2 pd=17.4 as=16.2 ps=17.4 w=6 l=0.6
X3 a_65240_1380# row_drive preamp_iso_tail_ext vss_escape sky130_fd_pr__nfet_01v8 ad=3.36 pd=8 as=3.12 ps=7.6 w=1.2 l=0.6
X4 decision_p latch_sense_p_ext tail_ext vss_escape sky130_fd_pr__nfet_01v8 ad=3.36 pd=8 as=3.12 ps=7.6 w=1.2 l=0.6
X5 vdd_ext reset decision_n vdd_ext sky130_fd_pr__pfet_01v8 ad=3.12 pd=7.6 as=3.36 ps=8 w=1.2 l=0.6
X6 tail_ext vdd_ext decision_n vss_escape sky130_fd_pr__nfet_01v8 ad=3.12 pd=7.6 as=3.36 ps=8 w=1.2 l=0.6
X7 decision_p decision_n vdd_ext vdd_ext sky130_fd_pr__pfet_01v8 ad=3.36 pd=8 as=3.12 ps=7.6 w=1.2 l=0.6
X8 tail_ext decision_p decision_n vss_escape sky130_fd_pr__nfet_01v8 ad=3.12 pd=7.6 as=3.36 ps=8 w=1.2 l=0.6
X9 latch_sense_p_ext row_drive iso_tail_ext vss_escape sky130_fd_pr__nfet_01v8 ad=3.36 pd=8 as=3.12 ps=7.6 w=1.2 l=0.6
X10 iso_tail_ext sar_comparator_input vdd_ext vss_escape sky130_fd_pr__nfet_01v8 ad=3.12 pd=7.6 as=3.36 ps=8 w=1.2 l=0.6
X11 decision_p reset vdd_ext vdd_ext sky130_fd_pr__pfet_01v8 ad=3.36 pd=8 as=3.12 ps=7.6 w=1.2 l=0.6
X12 decision_p decision_n tail_ext vss_escape sky130_fd_pr__nfet_01v8 ad=3.36 pd=8 as=3.12 ps=7.6 w=1.2 l=0.6
C0 m1_68300_3080# preamp_iso_tail_ext 0.01748f
C1 sar_readout_12b_0.vdd vdd_ext 1.39936f
C2 decision_p tail_ext 0.48065f
C3 row_dac_10b_0.vss row_drive 1.08123f
C4 m1_65180_1400# a_65240_1380# 0.06384f
C5 decision_n tail_ext 0.48065f
C6 sar_readout_12b_0.vss row_drive 0.36487f
C7 m1_65180_1400# latch_sense_p_ext 2.70428f
C8 shared_converter_mux_0.vdd row_drive 0.00246f
C9 eval tail_ext 0.36751f
C10 latch_sense_p_ext iso_tail_ext 0.21022f
C11 m1_65180_1400# preamp_iso_tail_ext 0.27201f
C12 a_65240_1380# vdd_ext 0.02574f
C13 vdd_ext preamp_iso_tail_ext 0.26648f
C14 shared_converter_mux_0.mux_bus vss 0.03132f
C15 m1_68300_3080# row_drive 2.68356f
C16 m1_65180_1400# row_drive 4.46293f
C17 row_dac_10b_0.vss row_dac_10b_0.vdd 0.78467f
C18 iso_tail_ext row_drive 2.44092f
C19 row_dac_10b_0.vdd row_drive 1.11523f
C20 sar_readout_12b_0.vss iso_tail_ext 0.59891f
C21 vdd_ext row_drive 3.99812f
C22 sar_readout_12b_0.vss vdd_ext 0.93663f
C23 shared_converter_mux_0.vdd vdd_ext 0
C24 shared_converter_mux_0.vss row_drive 0.00246f
C25 reset vdd_ext 4.48789f
C26 latch_sense_p_ext tail_ext 0.0334f
C27 m1_65180_1400# m1_68300_3080# 0
C28 decision_n decision_p 2.54301f
C29 m1_68300_3080# vdd_ext 0.22292f
C30 m1_65180_1400# iso_tail_ext 0.70586f
C31 m1_65180_1400# vdd_ext 11.3013f
C32 vdd_ext iso_tail_ext 0.56445f
C33 latch_sense_p_ext vss 0.23329f
C34 vdd_ext shared_converter_mux_0.vss 0
C35 reset tail_ext 0.17577f
C36 m2_64900_1400# sar_comparator_input 0.30723f
C37 vss row_drive 0.22445f
C38 decision_p latch_sense_p_ext 0.18428f
C39 shared_converter_mux_0.vdd vss 0.2816f
C40 vdd_ext tail_ext 2.019f
C41 vdd row_drive 0.1964f
C42 a_65240_1380# m2_64900_1400# 0.4047f
C43 shared_converter_mux_0.mux_bus row_drive 0.06281f
C44 m2_64900_1400# preamp_iso_tail_ext 0.33816f
C45 shared_converter_mux_0.vdd shared_converter_mux_0.mux_bus 1.55306f
C46 a_65240_1380# sar_comparator_input 0.06962f
C47 decision_p reset 0.376f
C48 preamp_iso_tail_ext sar_comparator_input 0.2186f
C49 vdd_ext vss 0.42787f
C50 decision_n reset 0.31048f
C51 m2_64900_1400# row_drive 0.03396f
C52 a_65240_1380# preamp_iso_tail_ext 0.03291f
C53 vdd_ext shared_converter_mux_0.mux_bus 0.00217f
C54 sar_comparator_input row_drive 14.9297f
C55 shared_converter_mux_0.mux_bus shared_converter_mux_0.vss 1.56188f
C56 decision_p vdd_ext 3.8282f
C57 decision_n vdd_ext 4.12248f
C58 sar_readout_12b_0.vdd row_drive 0.84035f
C59 m1_68300_3080# m2_64900_1400# 0
C60 sar_readout_12b_0.vss sar_readout_12b_0.vdd 0.49712f
C61 vdd_ext eval 0
C62 a_65240_1380# row_drive 0.01809f
C63 m1_65180_1400# m2_64900_1400# 0.14191f
C64 latch_sense_p_ext row_drive 0.76057f
C65 preamp_iso_tail_ext row_drive 0.31468f
C66 vdd_ext m2_64900_1400# 0.53512f
C67 m1_68300_3080# sar_comparator_input 0
C68 m1_65180_1400# sar_comparator_input 0.92074f
C69 iso_tail_ext sar_comparator_input 0.16395f
C70 vdd_ext sar_comparator_input 1.19698f
C71 a_65240_1380# m1_68300_3080# 0
C72 sar_readout_12b_0.vdd iso_tail_ext 0.27367f
C73 vss vss_escape 36.2292f
C74 vdd vss_escape 36.7f
C75 preamp_iso_tail_ext vss_escape 46.67949f
C76 iso_tail_ext vss_escape 20.1978f
C77 decision_p vss_escape 22.33617f
C78 tail_ext vss_escape 0.24517p
C79 vdd_ext vss_escape 84.62925f
C80 m2_64900_1400# vss_escape 0.67976f ; **FLOATING
C81 sar_readout_12b_0.vss vss_escape 1.33686f ; **FLOATING
C82 row_dac_10b_0.vss vss_escape 1.40333f ; **FLOATING
C83 row_dac_10b_0.vdd vss_escape 1.33457f ; **FLOATING
C84 sar_readout_12b_0.vdd vss_escape 1.77614f ; **FLOATING
C85 m1_65180_1400# vss_escape 12.3834f ; **FLOATING
C86 m1_68300_3080# vss_escape 7.90194f ; **FLOATING
C87 shared_converter_mux_0.vss vss_escape 1.39454f ; **FLOATING
C88 shared_converter_mux_0.mux_bus vss_escape 2.86922f ; **FLOATING
C89 shared_converter_mux_0.vdd vss_escape 0.95985f ; **FLOATING
C90 a_65240_1380# vss_escape 32.62358f
.ends
