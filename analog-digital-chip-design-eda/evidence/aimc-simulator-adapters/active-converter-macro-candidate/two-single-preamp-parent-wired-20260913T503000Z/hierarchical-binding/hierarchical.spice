* SPICE3 file created from aimc_converter_macro_active_candidate.ext - technology: sky130A

.subckt preamp_n_parent_bound preamp_iso_tail_ext latch_sense_n_ext sar_comparator_input
+ vss_escape
X0 latch_sense_n_ext sar_comparator_input preamp_iso_tail_ext vss_escape sky130_fd_pr__nfet_01v8 ad=3.36 pd=8 as=3.12 ps=7.6 w=1.2 l=0.6
C0 sar_comparator_input preamp_iso_tail_ext 0.02892f
C1 sar_comparator_input latch_sense_n_ext 0.02459f
C2 preamp_iso_tail_ext latch_sense_n_ext 0.03982f
C3 latch_sense_n_ext vss_escape 1.37396f
C4 preamp_iso_tail_ext vss_escape 1.3736f
.ends

.subckt preamp_p_parent_bound preamp_iso_tail_ext latch_sense_p_ext row_drive vss_escape
X0 latch_sense_p_ext row_drive preamp_iso_tail_ext vss_escape sky130_fd_pr__nfet_01v8 ad=3.36 pd=8 as=3.12 ps=7.6 w=1.2 l=0.6
C0 latch_sense_p_ext preamp_iso_tail_ext 0.03982f
C1 row_drive preamp_iso_tail_ext 0.02892f
C2 row_drive latch_sense_p_ext 0.02459f
C3 latch_sense_p_ext vss_escape 1.37396f
C4 preamp_iso_tail_ext vss_escape 1.3736f
.ends

.subckt escaped_input_latch out_p out_n latch_sense_p latch_sense_n tail reset vdd
+ vss eval sense_p sense_n iso_tail vdd_active
X0 out_p out_n vdd_active vdd_active sky130_fd_pr__pfet_01v8 ad=3.36 pd=8 as=3.12 ps=7.6 w=1.2 l=0.6
X1 vdd reset out_n vdd sky130_fd_pr__pfet_01v8 ad=3.12 pd=7.6 as=3.36 ps=8 w=1.2 l=0.6
X2 tail out_p out_n vss sky130_fd_pr__nfet_01v8 ad=3.12 pd=7.6 as=3.36 ps=8 w=1.2 l=0.6
X3 out_p reset vdd vdd sky130_fd_pr__pfet_01v8 ad=3.36 pd=8 as=3.12 ps=7.6 w=1.2 l=0.6
X4 out_p out_n tail vss sky130_fd_pr__nfet_01v8 ad=3.36 pd=8 as=3.12 ps=7.6 w=1.2 l=0.6
X5 tail latch_sense_n out_n vss sky130_fd_pr__nfet_01v8 ad=3.12 pd=7.6 as=3.36 ps=8 w=1.2 l=0.6
X6 tail eval vss vss sky130_fd_pr__nfet_01v8 ad=16.2 pd=17.4 as=16.2 ps=17.4 w=6 l=0.6
X7 out_p latch_sense_p tail vss sky130_fd_pr__nfet_01v8 ad=3.36 pd=8 as=3.12 ps=7.6 w=1.2 l=0.6
X8 iso_tail sense_n latch_sense_n vss sky130_fd_pr__nfet_01v8 ad=3.12 pd=7.6 as=3.36 ps=8 w=1.2 l=0.6
X9 vdd_active out_p out_n vdd_active sky130_fd_pr__pfet_01v8 ad=3.12 pd=7.6 as=3.36 ps=8 w=1.2 l=0.6
X10 latch_sense_p sense_p iso_tail vss sky130_fd_pr__nfet_01v8 ad=3.36 pd=8 as=3.12 ps=7.6 w=1.2 l=0.6
C0 iso_tail sense_n 0.10725f
C1 tail latch_sense_n 0.0334f
C2 tail out_n 0.46979f
C3 iso_tail sense_p 0.26105f
C4 vdd out_n 0.77104f
C5 tail vdd_active 0.9938f
C6 tail out_p 0.46979f
C7 latch_sense_p out_p 0.18428f
C8 vdd out_p 0.76206f
C9 latch_sense_n out_n 0.18428f
C10 vdd_active out_n 3.16716f
C11 out_p out_n 2.54301f
C12 vdd_active out_p 3.06556f
C13 iso_tail latch_sense_p 0.20888f
C14 iso_tail latch_sense_n 0.20888f
C15 latch_sense_p sense_p 0.22977f
C16 latch_sense_n sense_n 0.22977f
C17 tail reset 0.16491f
C18 vdd reset 4.47121f
C19 reset out_n 0.31048f
C20 tail eval 0.35666f
C21 tail latch_sense_p 0.0334f
C22 tail vdd 0.9918f
C23 reset out_p 0.376f
C24 iso_tail vss 29.23796f
C25 latch_sense_n vss 1.7693f
C26 latch_sense_p vss 1.56796f
C27 out_n vss 13.58747f
C28 tail vss 89.03816f
C29 vdd_active vss 90.11912f
C30 vdd vss 78.65506f
.ends

.subckt aimc_converter_macro_active_candidate vss vdd row_drive sar_comparator_input
+ decision_p decision_n reset eval latch_sense_p_ext iso_tail_ext tail_ext vdd_ext
+ vss_escape_uq1 latch_sense_n_ext_uq1
Xphysical_preamp_n physical_preamp_n/preamp_iso_tail_ext physical_preamp_n/latch_sense_n_ext
+ physical_preamp_n/sar_comparator_input vss_escape_uq1 preamp_n_parent_bound
Xphysical_preamp_p physical_preamp_p/preamp_iso_tail_ext physical_preamp_p/latch_sense_p_ext
+ physical_preamp_p/row_drive vss_escape_uq1 preamp_p_parent_bound
Xconverter_latch_0 decision_p decision_n latch_sense_p_ext latch_sense_n_ext_uq1 tail_ext
+ reset vdd_ext vss_escape_uq1 eval row_drive sar_comparator_input iso_tail_ext vdd_ext
+ escaped_input_latch
C0 shared_converter_mux_0/mux_bus shared_converter_mux_0/vdd 1.55306f
C1 latch_sense_p_ext row_drive 0.47724f
C2 row_drive sar_readout_12b_0/vss 0.29433f
C3 vss shared_converter_mux_0/vdd 0.2816f
C4 shared_converter_mux_0/mux_bus row_drive 0.06281f
C5 vss latch_sense_n_ext_uq1 0.29037f
C6 m1_68300_3080# row_drive 2.68328f
C7 iso_tail_ext sar_comparator_input 0.05996f
C8 row_drive vss 0.22445f
C9 vdd_ext sar_comparator_input 1.06679f
C10 decision_n latch_sense_n_ext_uq1 0.19207f
C11 sar_readout_12b_0/vdd sar_readout_12b_0/vss 0.49712f
C12 latch_sense_n_ext_uq1 latch_sense_n_ext 0.08631f
C13 row_drive shared_converter_mux_0/vdd 0.00246f
C14 vdd_ext sar_comparator_input_uq0 0.0023f
C15 row_drive latch_sense_n_ext_uq1 1.07551f
C16 latch_sense_n_ext_uq1 latch_sense_p_ext_uq1 0.02096f
C17 iso_tail_ext latch_sense_p_ext -0.07937f
C18 vdd_ext latch_sense_p_ext 4.10659f
C19 shared_converter_mux_0/vss shared_converter_mux_0/mux_bus 1.56188f
C20 row_drive latch_sense_p_ext_uq1 0.01259f
C21 iso_tail_ext sar_readout_12b_0/vss 0.60045f
C22 vdd_ext sar_readout_12b_0/vss 0.93663f
C23 tail_ext latch_sense_p_ext 0.96249f
C24 row_dac_10b_0/vdd row_drive 1.11462f
C25 vdd_ext shared_converter_mux_0/mux_bus 0.00217f
C26 vdd_ext decision_p 0
C27 vdd_ext eval 0
C28 vdd_ext m1_68300_3080# 0.24419f
C29 tail_ext decision_p 0.01085f
C30 tail_ext eval 0.01085f
C31 vdd_ext reset 0.01669f
C32 vdd_ext vss 0.19458f
C33 sar_readout_12b_0/vdd row_drive 0.58157f
C34 tail_ext reset 0.01085f
C35 tail_ext decision_n 0.01085f
C36 vdd_ext shared_converter_mux_0/vdd 0
C37 m4_45060_36440# latch_sense_n_ext_uq1 0.04404f
C38 m4_51060_36440# vdd_ext 0.01404f
C39 iso_tail_ext latch_sense_n_ext_uq1 -0.07889f
C40 shared_converter_mux_0/vss row_drive 0.00246f
C41 vdd_ext latch_sense_n_ext_uq1 4.68954f
C42 vdd_ext latch_sense_n_ext 0.00495f
C43 m4_45060_36440# row_drive 0.09668f
C44 tail_ext latch_sense_n_ext_uq1 1.06262f
C45 iso_tail_ext row_drive 2.13599f
C46 row_dac_10b_0/vss row_drive 1.08123f
C47 vdd_ext row_drive 3.74725f
C48 vdd_ext latch_sense_p_ext_uq1 0.00465f
C49 row_dac_10b_0/vdd row_dac_10b_0/vss 0.78467f
C50 vdd row_drive 0.1964f
C51 latch_sense_p_ext decision_p 0.19207f
C52 latch_sense_p_ext eval 0.19752f
C53 latch_sense_n_ext_uq1 sar_comparator_input -0.1861f
C54 sar_readout_12b_0/vdd iso_tail_ext 0.27521f
C55 sar_readout_12b_0/vdd vdd_ext 1.39936f
C56 latch_sense_p_ext reset 0.19529f
C57 latch_sense_p_ext vss 0.29037f
C58 row_drive sar_comparator_input 5.22878f
C59 m4_51060_36440# sar_comparator_input_uq0 0.09668f
C60 latch_sense_n_ext_uq1 sar_comparator_input_uq0 0.28188f
C61 shared_converter_mux_0/mux_bus vss 0.03132f
C62 sar_comparator_input_uq0 latch_sense_n_ext 0.03952f
C63 shared_converter_mux_0/vss vdd_ext 0
C64 row_drive sar_comparator_input_uq0 0.12269f
C65 m4_45060_36440# vdd_ext 0.01404f
C66 vdd_ext iso_tail_ext 0.86179f
C67 vss vss_escape_uq1 36.7f
C68 vdd vss_escape_uq1 36.7f
C69 m4_51060_36440# vss_escape_uq1 0.13562f **FLOATING
C70 m4_45060_36440# vss_escape_uq1 0.11362f **FLOATING
C71 sar_comparator_input_uq0 vss_escape_uq1 6.44808f **FLOATING
C72 m1_68300_3080# vss_escape_uq1 7.89552f **FLOATING
C73 latch_sense_n_ext vss_escape_uq1 1.46716f **FLOATING
C74 latch_sense_p_ext_uq1 vss_escape_uq1 0.31629f **FLOATING
C75 iso_tail_ext vss_escape_uq1 -1.23816f
C76 sar_comparator_input vss_escape_uq1 11.80296f
C77 latch_sense_n_ext_uq1 vss_escape_uq1 18.2689f
C78 latch_sense_p_ext vss_escape_uq1 -0.17286f
C79 decision_n vss_escape_uq1 3.8093f
C80 eval vss_escape_uq1 0.78348f
C81 row_drive vss_escape_uq1 49.4783f
C82 vdd_ext vss_escape_uq1 43.81244f
.ends
