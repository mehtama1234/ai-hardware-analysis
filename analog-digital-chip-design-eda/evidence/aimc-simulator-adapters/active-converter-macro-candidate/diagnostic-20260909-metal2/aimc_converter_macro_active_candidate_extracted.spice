* NGSPICE file created from aimc_converter_macro_active_candidate.ext - technology: sky130A

.subckt sky130_transistor_active_isolation_pair iso_tail iso_p iso_n sense_p sense_n
+ m1_3440_500# m1_1000_500# m2_900_1400# VSUBS
X0 iso_tail sense_n iso_n VSUBS sky130_fd_pr__nfet_01v8 ad=3.12 pd=7.6 as=3.36 ps=8 w=1.2 l=0.6
X1 iso_p sense_p iso_tail VSUBS sky130_fd_pr__nfet_01v8 ad=3.36 pd=8 as=3.12 ps=7.6 w=1.2 l=0.6
C0 sense_n iso_n 0.02157f
C1 m1_1000_500# iso_p 0.0015f
C2 m1_1000_500# m2_900_1400# 0.01113f
C3 sense_n m2_900_1400# 0.04273f
C4 m1_3440_500# sense_n 0.04555f
C5 iso_p iso_n 0.00782f
C6 m2_900_1400# iso_n 0.41846f
C7 sense_p iso_tail 0.12292f
C8 iso_p m2_900_1400# 0.41846f
C9 m1_3440_500# iso_n 0.0015f
C10 m1_3440_500# m2_900_1400# 0.01113f
C11 m1_1000_500# iso_tail 0.0015f
C12 sense_n iso_tail 0.11179f
C13 iso_tail iso_n 0.05717f
C14 sense_p m1_1000_500# 0.04555f
C15 iso_tail iso_p 0.05749f
C16 iso_tail m2_900_1400# 0.34398f
C17 m1_3440_500# iso_tail 0.0015f
C18 sense_p iso_p 0.02157f
C19 sense_p m2_900_1400# 0.04273f
C20 iso_n VSUBS 1.04634f
C21 iso_p VSUBS 1.04634f
C22 iso_tail VSUBS 4.24257f
C23 m2_900_1400# VSUBS 1.01648f
C24 m1_3440_500# VSUBS 0.31893f
C25 m1_1000_500# VSUBS 0.31893f
.ends

.subckt escaped_input_latch out_p out_n latch_sense_p latch_sense_n tail reset vdd
+ vss eval sense_p sense_n iso_tail vdd_active
X0 out_p out_n vdd_active vdd_active sky130_fd_pr__pfet_01v8 ad=3.36 pd=8 as=3.12 ps=7.6 w=1.2 l=0.6
X1 vdd reset out_n vdd sky130_fd_pr__pfet_01v8 ad=3.12 pd=7.6 as=3.36 ps=8 w=1.2 l=0.6
X2 tail out_p out_n vss sky130_fd_pr__nfet_01v8 ad=3.12 pd=7.6 as=3.36 ps=8 w=1.2 l=0.6
X3 out_p reset vdd vdd sky130_fd_pr__pfet_01v8 ad=3.36 pd=8 as=3.12 ps=7.6 w=1.2 l=0.6
X4 out_p out_n tail vss sky130_fd_pr__nfet_01v8 ad=3.36 pd=8 as=3.12 ps=7.6 w=1.2 l=0.6
X5 tail latch_sense_n out_n vss sky130_fd_pr__nfet_01v8 ad=3.12 pd=7.6 as=3.36 ps=8 w=1.2 l=0.6
X6 tail eval vss vss sky130_fd_pr__nfet_01v8 ad=16.2 pd=17.4 as=16.2 ps=17.4 w=6 l=0.6
X7 out_p latch_sense_p tail vss sky130_fd_pr__nfet_01v8 ad=3.36 pd=8 as=3.12 ps=7.6 w=1.2 l=0.6
X8 iso_tail sense_n latch_sense_n vss sky130_fd_pr__nfet_01v8 ad=3.12 pd=7.6 as=3.36 ps=8 w=1.2 l=0.6
X9 vdd_active out_p out_n vdd_active sky130_fd_pr__pfet_01v8 ad=3.12 pd=7.6 as=3.36 ps=8 w=1.2 l=0.6
X10 latch_sense_p sense_p iso_tail vss sky130_fd_pr__nfet_01v8 ad=3.36 pd=8 as=3.12 ps=7.6 w=1.2 l=0.6
C0 out_n out_p 2.54301f
C1 out_n reset 0.31048f
C2 out_n vdd 0.77104f
C3 sense_n iso_tail 0.10725f
C4 reset out_p 0.376f
C5 vdd out_p 0.76206f
C6 vdd_active tail 0.9938f
C7 latch_sense_p out_p 0.18428f
C8 reset vdd 4.47121f
C9 out_n tail 0.46979f
C10 latch_sense_n tail 0.0334f
C11 eval tail 0.35666f
C12 latch_sense_n iso_tail 0.20888f
C13 latch_sense_p sense_p 0.22977f
C14 latch_sense_n sense_n 0.22977f
C15 tail out_p 0.46979f
C16 vdd_active out_n 3.16716f
C17 tail reset 0.16491f
C18 tail vdd 0.9918f
C19 latch_sense_p tail 0.0334f
C20 latch_sense_p iso_tail 0.20888f
C21 vdd_active out_p 3.06556f
C22 out_n latch_sense_n 0.18428f
C23 sense_p iso_tail 0.26105f
C24 iso_tail vss 29.23796f
C25 latch_sense_n vss 1.7693f
C26 latch_sense_p vss 1.56796f
C27 out_n vss 13.58747f
C28 tail vss 89.03816f
C29 vdd_active vss 90.11912f
C30 vdd vss 78.65506f
.ends

.subckt aimc_converter_macro_active_candidate vss vdd row_drive sar_comparator_input
+ decision_p decision_n reset eval vss_escape latch_sense_p_ext latch_sense_n_ext
+ iso_tail_ext tail_ext vdd_ext
Xphysical_preamp_0 physical_preamp_0/iso_tail physical_preamp_0/iso_p physical_preamp_0/iso_n
+ physical_preamp_0/sense_p physical_preamp_0/sense_n sar_comparator_input physical_preamp_0/m1_1000_500#
+ physical_preamp_0/m2_900_1400# vss_escape sky130_transistor_active_isolation_pair
Xconverter_latch_0 decision_p decision_n latch_sense_p_ext latch_sense_n_ext tail_ext
+ reset vdd_ext vss_escape eval row_drive sar_comparator_input iso_tail_ext vdd_ext
+ escaped_input_latch
C0 sar_comparator_input physical_preamp_0/m1_1000_500# 0.02555f
C1 physical_preamp_0/iso_p sar_comparator_input 0.02717f
C2 physical_preamp_0/m2_900_1400# sar_comparator_input 0.16477f
C3 row_drive iso_tail_ext 0.26323f
C4 row_drive sar_readout_12b_0/vss 0.21493f
C5 row_drive row_dac_10b_0/vdd 1.11409f
C6 shared_converter_mux_0/vdd shared_converter_mux_0/mux_bus 1.55306f
C7 shared_converter_mux_0/vss shared_converter_mux_0/mux_bus 1.56188f
C8 tail_ext decision_n 0.01085f
C9 row_drive shared_converter_mux_0/mux_bus 0.06281f
C10 vss latch_sense_n_ext 0.23329f
C11 shared_converter_mux_0/vdd vss 0.2816f
C12 decision_p vdd_ext 0
C13 physical_preamp_0/iso_n sar_comparator_input 0.027f
C14 physical_preamp_0/sense_n sar_comparator_input 0.02993f
C15 row_drive vss 0.22445f
C16 sar_readout_12b_0/vdd vdd_ext 1.39936f
C17 eval vdd_ext 0
C18 reset vdd_ext 0.01669f
C19 sar_readout_12b_0/vss iso_tail_ext 0.60149f
C20 physical_preamp_0/iso_tail sar_comparator_input 0.0361f
C21 row_dac_10b_0/vss row_drive 1.08123f
C22 sar_comparator_input iso_tail_ext 0.08712f
C23 vdd row_drive 0.1964f
C24 physical_preamp_0/sense_p physical_preamp_0/m1_1000_500# -0.00637f
C25 physical_preamp_0/m2_900_1400# physical_preamp_0/sense_p -0.00637f
C26 row_drive latch_sense_p_ext 0
C27 shared_converter_mux_0/mux_bus vss 0.03132f
C28 shared_converter_mux_0/vdd vdd_ext 0
C29 shared_converter_mux_0/vss vdd_ext 0
C30 row_drive vdd_ext 1.55835f
C31 row_drive sar_readout_12b_0/vdd 0.33461f
C32 row_dac_10b_0/vss row_dac_10b_0/vdd 0.78467f
C33 physical_preamp_0/iso_p physical_preamp_0/m1_1000_500# -0
C34 physical_preamp_0/m2_900_1400# physical_preamp_0/m1_1000_500# -0.01047f
C35 physical_preamp_0/m2_900_1400# physical_preamp_0/iso_p 0
C36 iso_tail_ext vdd_ext 0.31557f
C37 sar_readout_12b_0/vss vdd_ext 0.93663f
C38 physical_preamp_0/sense_p sar_comparator_input 0.04196f
C39 latch_sense_p_ext vss 0.23329f
C40 shared_converter_mux_0/mux_bus vdd_ext 0.00217f
C41 sar_comparator_input vdd_ext 0.07181f
C42 sar_readout_12b_0/vdd iso_tail_ext 0.27625f
C43 sar_readout_12b_0/vdd sar_readout_12b_0/vss 0.49712f
C44 tail_ext decision_p 0.01085f
C45 vss vdd_ext 0.19458f
C46 physical_preamp_0/m2_900_1400# physical_preamp_0/iso_n -0
C47 physical_preamp_0/sense_n physical_preamp_0/m2_900_1400# -0.00318f
C48 shared_converter_mux_0/vdd row_drive 0.00246f
C49 tail_ext eval 0.01085f
C50 shared_converter_mux_0/vss row_drive 0.00246f
C51 tail_ext reset 0.01085f
C52 physical_preamp_0/iso_tail physical_preamp_0/m1_1000_500# -0
C53 vss vss_escape 36.7f
C54 vdd vss_escape 36.7f
C55 m1_69940_2940# vss_escape 0.19727f ; **FLOATING
C56 iso_tail_ext vss_escape -0.88568f
C57 sar_comparator_input vss_escape 10.77027f
C58 decision_n vss_escape 3.8093f
C59 eval vss_escape 0.78348f
C60 row_drive vss_escape 7.1806f
C61 vdd_ext vss_escape 34.13324f
.ends
