* NGSPICE file created from aimc_converter_macro_active_candidate_flat_parallel.ext - technology: sky130A

.subckt aimc_converter_macro_active_candidate_flat_parallel vss vdd row_drive sar_comparator_input
+ decision_p decision_n reset eval vss_escape latch_sense_p_ext latch_sense_n_ext
+ iso_tail_ext tail_ext vdd_ext preamp_iso_tail_ext
X0 latch_sense_p_ext row_drive preamp_iso_tail_ext vss_escape sky130_fd_pr__nfet_01v8 ad=3.54 pd=8.3 as=3.3 ps=7.9 w=1.2 l=0.3
X1 vdd_ext decision_p decision_n vdd_ext sky130_fd_pr__pfet_01v8 ad=3.12 pd=7.6 as=3.36 ps=8 w=1.2 l=0.6
X2 tail_ext eval vss_escape vss_escape sky130_fd_pr__nfet_01v8 ad=16.2 pd=17.4 as=16.2 ps=17.4 w=6 l=0.6
X3 latch_sense_n_ext sar_comparator_input preamp_iso_tail_ext vss_escape sky130_fd_pr__nfet_01v8 ad=3.54 pd=8.3 as=3.3 ps=7.9 w=1.2 l=0.3
X4 latch_sense_p_ext row_drive preamp_iso_tail_ext vss_escape sky130_fd_pr__nfet_01v8 ad=3.54 pd=8.3 as=3.3 ps=7.9 w=1.2 l=0.3
X5 decision_p latch_sense_p_ext tail_ext vss_escape sky130_fd_pr__nfet_01v8 ad=3.36 pd=8 as=3.12 ps=7.6 w=1.2 l=0.6
X6 latch_sense_p_ext row_drive preamp_iso_tail_ext vss_escape sky130_fd_pr__nfet_01v8 ad=3.72 pd=8.6 as=3.12 ps=7.6 w=1.2 l=0.3
X7 vdd_ext reset decision_n vdd_ext sky130_fd_pr__pfet_01v8 ad=3.12 pd=7.6 as=3.36 ps=8 w=1.2 l=0.6
X8 tail_ext latch_sense_n_ext decision_n vss_escape sky130_fd_pr__nfet_01v8 ad=3.12 pd=7.6 as=3.36 ps=8 w=1.2 l=0.6
X9 decision_p decision_n vdd_ext vdd_ext sky130_fd_pr__pfet_01v8 ad=3.36 pd=8 as=3.12 ps=7.6 w=1.2 l=0.6
X10 tail_ext decision_p decision_n vss_escape sky130_fd_pr__nfet_01v8 ad=3.12 pd=7.6 as=3.36 ps=8 w=1.2 l=0.6
X11 latch_sense_p_ext row_drive iso_tail_ext vss_escape sky130_fd_pr__nfet_01v8 ad=3.36 pd=8 as=3.12 ps=7.6 w=1.2 l=0.6
X12 iso_tail_ext sar_comparator_input latch_sense_n_ext vss_escape sky130_fd_pr__nfet_01v8 ad=3.12 pd=7.6 as=3.36 ps=8 w=1.2 l=0.6
X13 latch_sense_n_ext sar_comparator_input preamp_iso_tail_ext vss_escape sky130_fd_pr__nfet_01v8 ad=3.54 pd=8.3 as=3.3 ps=7.9 w=1.2 l=0.3
X14 latch_sense_n_ext sar_comparator_input preamp_iso_tail_ext vss_escape sky130_fd_pr__nfet_01v8 ad=3.72 pd=8.6 as=3.12 ps=7.6 w=1.2 l=0.3
X15 decision_p reset vdd_ext vdd_ext sky130_fd_pr__pfet_01v8 ad=3.36 pd=8 as=3.12 ps=7.6 w=1.2 l=0.6
X16 decision_p decision_n tail_ext vss_escape sky130_fd_pr__nfet_01v8 ad=3.36 pd=8 as=3.12 ps=7.6 w=1.2 l=0.6
.ends
