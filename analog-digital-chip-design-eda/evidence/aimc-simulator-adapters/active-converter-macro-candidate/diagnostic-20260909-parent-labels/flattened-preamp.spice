* NGSPICE file created from aimc_converter_macro_active_candidate_flat.ext - technology: sky130A

.subckt aimc_converter_macro_active_candidate_flat vss vdd row_drive sar_comparator_input
+ decision_p decision_n reset eval vss_escape latch_sense_p_ext latch_sense_n_ext
+ iso_tail_ext tail_ext vdd_ext preamp_iso_tail_ext
X0 physical_preamp_0.iso_tail physical_preamp_0.sense_n physical_preamp_0.iso_n vss_escape sky130_fd_pr__nfet_01v8 ad=3.12 pd=7.6 as=3.36 ps=8 w=1.2 l=0.6
X1 vdd_ext decision_p decision_n vdd_ext sky130_fd_pr__pfet_01v8 ad=3.12 pd=7.6 as=3.36 ps=8 w=1.2 l=0.6
X2 tail_ext eval vss_escape vss_escape sky130_fd_pr__nfet_01v8 ad=16.2 pd=17.4 as=16.2 ps=17.4 w=6 l=0.6
X3 physical_preamp_0.iso_p physical_preamp_0.sense_p physical_preamp_0.iso_tail vss_escape sky130_fd_pr__nfet_01v8 ad=3.36 pd=8 as=3.12 ps=7.6 w=1.2 l=0.6
X4 decision_p latch_sense_p_ext tail_ext vss_escape sky130_fd_pr__nfet_01v8 ad=3.36 pd=8 as=3.12 ps=7.6 w=1.2 l=0.6
X5 vdd_ext reset decision_n vdd_ext sky130_fd_pr__pfet_01v8 ad=3.12 pd=7.6 as=3.36 ps=8 w=1.2 l=0.6
X6 tail_ext latch_sense_n_ext decision_n vss_escape sky130_fd_pr__nfet_01v8 ad=3.12 pd=7.6 as=3.36 ps=8 w=1.2 l=0.6
X7 decision_p decision_n vdd_ext vdd_ext sky130_fd_pr__pfet_01v8 ad=3.36 pd=8 as=3.12 ps=7.6 w=1.2 l=0.6
X8 tail_ext decision_p decision_n vss_escape sky130_fd_pr__nfet_01v8 ad=3.12 pd=7.6 as=3.36 ps=8 w=1.2 l=0.6
X9 latch_sense_p_ext row_drive iso_tail_ext vss_escape sky130_fd_pr__nfet_01v8 ad=3.36 pd=8 as=3.12 ps=7.6 w=1.2 l=0.6
X10 iso_tail_ext sar_comparator_input latch_sense_n_ext vss_escape sky130_fd_pr__nfet_01v8 ad=3.12 pd=7.6 as=3.36 ps=8 w=1.2 l=0.6
X11 decision_p reset vdd_ext vdd_ext sky130_fd_pr__pfet_01v8 ad=3.36 pd=8 as=3.12 ps=7.6 w=1.2 l=0.6
X12 decision_p decision_n tail_ext vss_escape sky130_fd_pr__nfet_01v8 ad=3.36 pd=8 as=3.12 ps=7.6 w=1.2 l=0.6
C0 row_dac_10b_0.vss row_drive 1.08123f
C1 sar_readout_12b_0.vdd iso_tail_ext 0.27521f
C2 vss shared_converter_mux_0.mux_bus 0.03132f
C3 decision_p vdd_ext 3.8282f
C4 physical_preamp_0.iso_n physical_preamp_0.sense_n 0.02157f
C5 physical_preamp_0.sense_n vdd_ext 0.0039f
C6 physical_preamp_0.sense_p sar_comparator_input 0.04049f
C7 shared_converter_mux_0.vss vdd_ext 0
C8 sar_comparator_input iso_tail_ext 0.16721f
C9 vss latch_sense_p_ext 0.23329f
C10 sar_readout_12b_0.vss vdd_ext 0.93663f
C11 m2_64900_1400# physical_preamp_0.iso_n 0.41846f
C12 physical_preamp_0.iso_p row_drive 0.00133f
C13 m2_64900_1400# vdd_ext 0.07266f
C14 decision_n tail_ext 0.48065f
C15 sar_readout_12b_0.vdd vdd_ext 1.39936f
C16 latch_sense_p_ext iso_tail_ext 0.12577f
C17 row_drive latch_sense_n_ext 0.20099f
C18 decision_p tail_ext 0.48065f
C19 decision_n latch_sense_n_ext 0.18428f
C20 physical_preamp_0.iso_tail row_drive 0.02471f
C21 shared_converter_mux_0.mux_bus vdd_ext 0.00217f
C22 shared_converter_mux_0.vdd shared_converter_mux_0.mux_bus 1.55306f
C23 physical_preamp_0.iso_n sar_comparator_input 0.0285f
C24 sar_comparator_input vdd_ext 1.05718f
C25 eval vdd_ext 0
C26 m2_64900_1400# physical_preamp_0.iso_p 0.41846f
C27 physical_preamp_0.sense_n physical_preamp_0.iso_tail 0.11179f
C28 latch_sense_p_ext vdd_ext 3.43095f
C29 vss vdd_ext 0.20794f
C30 shared_converter_mux_0.vdd vss 0.2816f
C31 row_drive row_dac_10b_0.vdd 1.11462f
C32 vdd row_drive 0.1964f
C33 physical_preamp_0.sense_p vdd_ext 0.03284f
C34 m2_64900_1400# physical_preamp_0.iso_tail 0.34398f
C35 iso_tail_ext vdd_ext 0.86179f
C36 physical_preamp_0.iso_p sar_comparator_input 0.02717f
C37 reset vdd_ext 4.48789f
C38 sar_comparator_input latch_sense_n_ext 0.04279f
C39 tail_ext eval 0.36751f
C40 sar_comparator_input physical_preamp_0.iso_tail 0.03759f
C41 latch_sense_p_ext tail_ext 0.0334f
C42 physical_preamp_0.iso_n vdd_ext 0.0106f
C43 shared_converter_mux_0.vdd vdd_ext 0
C44 physical_preamp_0.sense_p physical_preamp_0.iso_p 0.02157f
C45 vss latch_sense_n_ext 0.23329f
C46 reset tail_ext 0.17577f
C47 decision_p decision_n 2.54301f
C48 iso_tail_ext latch_sense_n_ext 0.12577f
C49 physical_preamp_0.sense_p physical_preamp_0.iso_tail 0.12292f
C50 shared_converter_mux_0.vss row_drive 0.00246f
C51 sar_readout_12b_0.vss row_drive 0.29422f
C52 m2_64900_1400# row_drive 0.00382f
C53 row_drive sar_readout_12b_0.vdd 0.57218f
C54 physical_preamp_0.iso_n physical_preamp_0.iso_p 0.00782f
C55 physical_preamp_0.iso_p vdd_ext 0.02484f
C56 tail_ext vdd_ext 1.9856f
C57 latch_sense_n_ext vdd_ext 3.48444f
C58 shared_converter_mux_0.mux_bus row_drive 0.06281f
C59 physical_preamp_0.iso_n physical_preamp_0.iso_tail 0.05717f
C60 physical_preamp_0.iso_tail vdd_ext 0.30577f
C61 sar_comparator_input row_drive 5.23145f
C62 m2_64900_1400# physical_preamp_0.sense_n 0.03955f
C63 sar_readout_12b_0.vss sar_readout_12b_0.vdd 0.49712f
C64 latch_sense_p_ext row_drive 0.24412f
C65 preamp_iso_tail_ext m1_69940_2940# 0.03103f
C66 vss row_drive 0.22445f
C67 shared_converter_mux_0.vss shared_converter_mux_0.mux_bus 1.56188f
C68 sar_comparator_input physical_preamp_0.sense_n 0.07548f
C69 physical_preamp_0.sense_p row_drive 0.08156f
C70 latch_sense_p_ext decision_p 0.18428f
C71 latch_sense_n_ext tail_ext 0.0334f
C72 row_drive iso_tail_ext 1.97962f
C73 physical_preamp_0.iso_p physical_preamp_0.iso_tail 0.05749f
C74 m2_64900_1400# sar_comparator_input 0.1759f
C75 decision_n reset 0.31048f
C76 row_dac_10b_0.vss row_dac_10b_0.vdd 0.78467f
C77 decision_p reset 0.376f
C78 row_drive vdd_ext 2.69688f
C79 shared_converter_mux_0.vdd row_drive 0.00246f
C80 sar_readout_12b_0.vss iso_tail_ext 0.60045f
C81 physical_preamp_0.sense_p m2_64900_1400# 0.03637f
C82 decision_n vdd_ext 3.9382f
C83 preamp_iso_tail_ext vss_escape 0.18641f
C84 vss vss_escape 36.2292f
C85 vdd vss_escape 36.7f
C86 iso_tail_ext vss_escape 55.47765f
C87 latch_sense_n_ext vss_escape 8.9128f
C88 latch_sense_p_ext vss_escape 24.51655f
C89 decision_p vss_escape 7.45999f
C90 tail_ext vss_escape 81.67176f
C91 vdd_ext vss_escape 0.25961p
C92 m2_64900_1400# vss_escape 0.72762f ; **FLOATING
C93 sar_readout_12b_0.vss vss_escape 1.33686f ; **FLOATING
C94 row_dac_10b_0.vss vss_escape 1.40333f ; **FLOATING
C95 row_dac_10b_0.vdd vss_escape 1.33457f ; **FLOATING
C96 sar_readout_12b_0.vdd vss_escape 1.77614f ; **FLOATING
C97 m1_69940_2940# vss_escape 0.19727f ; **FLOATING
C98 shared_converter_mux_0.vss vss_escape 1.39454f ; **FLOATING
C99 shared_converter_mux_0.mux_bus vss_escape 2.86922f ; **FLOATING
C100 shared_converter_mux_0.vdd vss_escape 0.95985f ; **FLOATING
C101 physical_preamp_0.iso_n vss_escape 1.04634f
C102 physical_preamp_0.iso_p vss_escape 1.04634f
C103 physical_preamp_0.iso_tail vss_escape 4.2324f
.ends
