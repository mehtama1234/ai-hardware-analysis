* NGSPICE file created from preamp_port_candidate.ext - technology: sky130A

.subckt preamp_port_candidate preamp_iso_tail_ext latch_sense_p_ext latch_sense_n_ext
+ row_drive sar_comparator_input vss_escape
X0 preamp_iso_tail_ext a_3560_600# latch_sense_n_ext vss_escape sky130_fd_pr__nfet_01v8 ad=3.12 pd=7.6 as=3.36 ps=8 w=1.2 l=0.6
X1 latch_sense_p_ext a_1120_600# preamp_iso_tail_ext vss_escape sky130_fd_pr__nfet_01v8 ad=3.36 pd=8 as=3.12 ps=7.6 w=1.2 l=0.6
C0 preamp_iso_tail_ext latch_sense_n_ext 0.05717f
C1 latch_sense_n_ext latch_sense_p_ext 0.00782f
C2 sar_comparator_input latch_sense_n_ext 0.0015f
C3 a_3560_600# latch_sense_n_ext 0.02157f
C4 preamp_iso_tail_ext row_drive 0.0015f
C5 m2_900_1400# latch_sense_n_ext 0.41846f
C6 row_drive latch_sense_p_ext 0.0015f
C7 preamp_iso_tail_ext latch_sense_p_ext 0.05749f
C8 sar_comparator_input preamp_iso_tail_ext 0.0015f
C9 preamp_iso_tail_ext a_3560_600# 0.11179f
C10 a_1120_600# row_drive 0.07991f
C11 preamp_iso_tail_ext a_1120_600# 0.12292f
C12 m2_900_1400# row_drive 0.01146f
C13 sar_comparator_input a_3560_600# 0.07991f
C14 preamp_iso_tail_ext m2_900_1400# 0.34398f
C15 a_1120_600# latch_sense_p_ext 0.02157f
C16 m2_900_1400# latch_sense_p_ext 0.41846f
C17 sar_comparator_input m2_900_1400# 0.01146f
C18 m2_900_1400# a_3560_600# 0.04273f
C19 m2_900_1400# a_1120_600# 0.04273f
C20 sar_comparator_input vss_escape 0.39002f
C21 row_drive vss_escape 0.39002f
C22 latch_sense_n_ext vss_escape 1.04634f
C23 latch_sense_p_ext vss_escape 1.04634f
C24 preamp_iso_tail_ext vss_escape 4.23383f
C25 m2_900_1400# vss_escape 1.01648f ; **FLOATING
.ends
