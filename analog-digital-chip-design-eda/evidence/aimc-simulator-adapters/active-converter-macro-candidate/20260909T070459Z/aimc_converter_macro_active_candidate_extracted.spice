* NGSPICE file created from aimc_converter_macro_active_candidate.ext - technology: sky130A

.subckt sky130_transistor_active_isolation_pair iso_tail iso_p iso_n sense_p sense_n
+ m1_3440_500# m1_1000_500# m2_900_1400# VSUBS
X0 iso_tail sense_n iso_n VSUBS sky130_fd_pr__nfet_01v8 ad=3.12 pd=7.6 as=3.36 ps=8 w=1.2 l=0.6
X1 iso_p sense_p iso_tail VSUBS sky130_fd_pr__nfet_01v8 ad=3.36 pd=8 as=3.12 ps=7.6 w=1.2 l=0.6
C0 m1_1000_500# iso_p 0.0015f
C1 m1_1000_500# iso_tail 0.0015f
C2 iso_n sense_n 0.02157f
C3 m2_900_1400# iso_n 0.41846f
C4 iso_tail sense_n 0.11179f
C5 m2_900_1400# iso_p 0.41846f
C6 m2_900_1400# iso_tail 0.34398f
C7 sense_p m1_1000_500# 0.04555f
C8 iso_p iso_n 0.00782f
C9 iso_tail iso_n 0.05717f
C10 iso_tail iso_p 0.05749f
C11 m2_900_1400# sense_p 0.04273f
C12 m1_3440_500# sense_n 0.04555f
C13 m2_900_1400# m1_3440_500# 0.01113f
C14 m2_900_1400# m1_1000_500# 0.01113f
C15 sense_p iso_p 0.02157f
C16 sense_p iso_tail 0.12292f
C17 m1_3440_500# iso_n 0.0015f
C18 iso_tail m1_3440_500# 0.0015f
C19 m2_900_1400# sense_n 0.04273f
C20 iso_n VSUBS 1.04634f
C21 iso_p VSUBS 1.04634f
C22 iso_tail VSUBS 4.24257f
C23 m2_900_1400# VSUBS 1.01648f
C24 m1_3440_500# VSUBS 0.31893f
C25 m1_1000_500# VSUBS 0.31893f
.ends

.subckt escaped_input_latch out_p out_n latch_sense_p latch_sense_n tail reset vdd
+ vss eval sense_p sense_n iso_tail vdd_active
X0 out_p out_n vdd_active vdd_active sky130_fd_pr__pfet_01v8 ad=3.36 pd=8 as=3.12 ps=7.6 w=1.2 l=0.6
X1 vdd reset out_n vdd sky130_fd_pr__pfet_01v8 ad=3.12 pd=7.6 as=3.36 ps=8 w=1.2 l=0.6
X2 tail out_p out_n vss sky130_fd_pr__nfet_01v8 ad=3.12 pd=7.6 as=3.36 ps=8 w=1.2 l=0.6
X3 out_p reset vdd vdd sky130_fd_pr__pfet_01v8 ad=3.36 pd=8 as=3.12 ps=7.6 w=1.2 l=0.6
X4 out_p out_n tail vss sky130_fd_pr__nfet_01v8 ad=3.36 pd=8 as=3.12 ps=7.6 w=1.2 l=0.6
X5 tail latch_sense_n out_n vss sky130_fd_pr__nfet_01v8 ad=3.12 pd=7.6 as=3.36 ps=8 w=1.2 l=0.6
X6 tail eval vss vss sky130_fd_pr__nfet_01v8 ad=16.2 pd=17.4 as=16.2 ps=17.4 w=6 l=0.6
X7 out_p latch_sense_p tail vss sky130_fd_pr__nfet_01v8 ad=3.36 pd=8 as=3.12 ps=7.6 w=1.2 l=0.6
X8 iso_tail sense_n latch_sense_n vss sky130_fd_pr__nfet_01v8 ad=3.12 pd=7.6 as=3.36 ps=8 w=1.2 l=0.6
X9 vdd_active out_p out_n vdd_active sky130_fd_pr__pfet_01v8 ad=3.12 pd=7.6 as=3.36 ps=8 w=1.2 l=0.6
X10 latch_sense_p sense_p iso_tail vss sky130_fd_pr__nfet_01v8 ad=3.36 pd=8 as=3.12 ps=7.6 w=1.2 l=0.6
C0 out_n reset 0.31048f
C1 out_n tail 0.46979f
C2 vdd out_p 0.76206f
C3 sense_n latch_sense_n 0.22977f
C4 tail eval 0.35666f
C5 vdd reset 4.47121f
C6 vdd tail 0.9918f
C7 latch_sense_n tail 0.0334f
C8 vdd_active out_n 3.16716f
C9 latch_sense_p out_p 0.18428f
C10 reset out_p 0.376f
C11 tail out_p 0.46979f
C12 iso_tail latch_sense_n 0.20888f
C13 latch_sense_p tail 0.0334f
C14 tail reset 0.16491f
C15 sense_n iso_tail 0.10725f
C16 latch_sense_p iso_tail 0.20888f
C17 latch_sense_p sense_p 0.22977f
C18 vdd out_n 0.77104f
C19 vdd_active out_p 3.06556f
C20 latch_sense_n out_n 0.18428f
C21 vdd_active tail 0.9938f
C22 out_n out_p 2.54301f
C23 iso_tail sense_p 0.26105f
C24 iso_tail vss 29.23796f
C25 latch_sense_n vss 1.7693f
C26 latch_sense_p vss 1.56796f
C27 out_n vss 13.58747f
C28 tail vss 89.03816f
C29 vdd_active vss 90.11912f
C30 vdd vss 78.65506f
.ends

.subckt aimc_converter_macro_active_candidate vss vdd row_drive sar_comparator_input
+ decision_p decision_n reset eval vss_escape vdd_ext iso_tail_ext tail_ext
Xphysical_preamp_0 physical_preamp_0/iso_tail physical_preamp_0/iso_p physical_preamp_0/iso_n
+ physical_preamp_0/sense_p physical_preamp_0/sense_n sar_comparator_input row_drive
+ vdd_ext vss_escape sky130_transistor_active_isolation_pair
Xconverter_latch_0 decision_p decision_n vdd_ext vdd_ext tail_ext reset vdd_ext vss_escape
+ eval row_drive sar_comparator_input iso_tail_ext vdd_ext escaped_input_latch
C0 sar_comparator_input physical_preamp_0/iso_n 0.027f
C1 shared_converter_mux_0/mux_bus shared_converter_mux_0/vdd 1.55306f
C2 sar_comparator_input physical_preamp_0/iso_tail 0.03267f
C3 vdd_ext row_drive 2.79321f
C4 physical_preamp_0/sense_p row_drive 0.0365f
C5 sar_comparator_input iso_tail_ext 0.05996f
C6 iso_tail_ext sar_readout_12b_0/vss 0.60045f
C7 shared_converter_mux_0/mux_bus vss 0.03132f
C8 sar_readout_12b_0/vdd sar_readout_12b_0/vss 0.49712f
C9 sar_comparator_input physical_preamp_0/iso_p 0.02717f
C10 vdd_ext shared_converter_mux_0/vdd 0
C11 vdd_ext decision_p 0
C12 tail_ext reset 0.01085f
C13 shared_converter_mux_0/mux_bus shared_converter_mux_0/vss 1.56188f
C14 row_dac_10b_0/vdd row_dac_10b_0/vss 0.78467f
C15 sar_comparator_input physical_preamp_0/sense_n 0.02993f
C16 tail_ext eval 0.01085f
C17 sar_readout_12b_0/vdd iso_tail_ext 0.27521f
C18 vss vdd_ext 0.66116f
C19 row_drive shared_converter_mux_0/vdd 0.00246f
C20 vss row_drive 0.22445f
C21 sar_comparator_input vdd_ext 0.98592f
C22 vdd_ext sar_readout_12b_0/vss 0.93663f
C23 physical_preamp_0/sense_p sar_comparator_input 0.04049f
C24 vdd_ext shared_converter_mux_0/vss 0
C25 sar_comparator_input row_drive 5.23145f
C26 row_drive sar_readout_12b_0/vss 0.29422f
C27 vdd_ext physical_preamp_0/iso_n 0.07669f
C28 vdd_ext physical_preamp_0/iso_tail 0.72109f
C29 row_dac_10b_0/vdd row_drive 1.11462f
C30 iso_tail_ext vdd_ext 0.48802f
C31 shared_converter_mux_0/vss row_drive 0.00246f
C32 vss shared_converter_mux_0/vdd 0.2816f
C33 physical_preamp_0/iso_tail row_drive 0.01722f
C34 sar_readout_12b_0/vdd vdd_ext 1.39936f
C35 vdd_ext reset 0.01669f
C36 iso_tail_ext row_drive 1.71857f
C37 vdd_ext eval 0
C38 shared_converter_mux_0/mux_bus vdd_ext 0.00217f
C39 vdd_ext physical_preamp_0/iso_p 0.12205f
C40 sar_readout_12b_0/vdd row_drive 0.57218f
C41 vdd row_drive 0.1964f
C42 tail_ext decision_n 0.01085f
C43 shared_converter_mux_0/mux_bus row_drive 0.06281f
C44 vdd_ext physical_preamp_0/sense_n 0.02275f
C45 row_drive physical_preamp_0/iso_p -0
C46 tail_ext decision_p 0.01085f
C47 row_drive row_dac_10b_0/vss 1.08123f
C48 physical_preamp_0/sense_p vdd_ext 0.06419f
C49 vss vss_escape 36.7f
C50 vdd vss_escape 36.7f
C51 iso_tail_ext vss_escape -1.05232f
C52 sar_comparator_input vss_escape 10.29193f
C53 decision_n vss_escape 3.8093f
C54 eval vss_escape 0.78348f
C55 row_drive vss_escape 19.0902f
C56 vdd_ext vss_escape 45.18349f
.ends
