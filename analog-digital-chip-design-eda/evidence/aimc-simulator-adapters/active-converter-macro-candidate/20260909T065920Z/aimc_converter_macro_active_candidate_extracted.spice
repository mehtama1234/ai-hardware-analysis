* NGSPICE file created from aimc_converter_macro_active_candidate.ext - technology: sky130A

.subckt sky130_transistor_active_isolation_pair iso_tail iso_p iso_n sense_p sense_n
+ m1_3440_500# m1_1000_500# m2_900_1400# VSUBS
X0 iso_tail sense_n iso_n VSUBS sky130_fd_pr__nfet_01v8 ad=3.12 pd=7.6 as=3.36 ps=8 w=1.2 l=0.6
X1 iso_p sense_p iso_tail VSUBS sky130_fd_pr__nfet_01v8 ad=3.36 pd=8 as=3.12 ps=7.6 w=1.2 l=0.6
C0 sense_n m2_900_1400# 0.04273f
C1 sense_n m1_3440_500# 0.04555f
C2 iso_p sense_p 0.02157f
C3 iso_p m2_900_1400# 0.41846f
C4 m2_900_1400# sense_p 0.04273f
C5 iso_tail m1_1000_500# 0.0015f
C6 iso_n sense_n 0.02157f
C7 sense_n iso_tail 0.11179f
C8 m1_3440_500# m2_900_1400# 0.01113f
C9 iso_p iso_n 0.00782f
C10 iso_p iso_tail 0.05749f
C11 iso_tail sense_p 0.12292f
C12 iso_n m2_900_1400# 0.41846f
C13 iso_n m1_3440_500# 0.0015f
C14 iso_tail m2_900_1400# 0.34398f
C15 iso_tail m1_3440_500# 0.0015f
C16 iso_n iso_tail 0.05717f
C17 iso_p m1_1000_500# 0.0015f
C18 sense_p m1_1000_500# 0.04555f
C19 m2_900_1400# m1_1000_500# 0.01113f
C20 iso_n VSUBS 1.04634f
C21 iso_p VSUBS 1.04634f
C22 iso_tail VSUBS 4.24257f
C23 m2_900_1400# VSUBS 1.01648f
C24 m1_3440_500# VSUBS 0.31893f
C25 m1_1000_500# VSUBS 0.31893f
.ends

.subckt escaped_input_latch out_p out_n latch_sense_p latch_sense_n tail reset vdd
+ vss eval sense_p sense_n iso_tail vdd_active
X0 out_p out_n vdd_active vdd_active sky130_fd_pr__pfet_01v8 ad=3.36 pd=8 as=3.12 ps=7.6 w=1.2 l=0.6
X1 vdd reset out_n vdd sky130_fd_pr__pfet_01v8 ad=3.12 pd=7.6 as=3.36 ps=8 w=1.2 l=0.6
X2 tail out_p out_n vss sky130_fd_pr__nfet_01v8 ad=3.12 pd=7.6 as=3.36 ps=8 w=1.2 l=0.6
X3 out_p reset vdd vdd sky130_fd_pr__pfet_01v8 ad=3.36 pd=8 as=3.12 ps=7.6 w=1.2 l=0.6
X4 out_p out_n tail vss sky130_fd_pr__nfet_01v8 ad=3.36 pd=8 as=3.12 ps=7.6 w=1.2 l=0.6
X5 tail latch_sense_n out_n vss sky130_fd_pr__nfet_01v8 ad=3.12 pd=7.6 as=3.36 ps=8 w=1.2 l=0.6
X6 tail eval vss vss sky130_fd_pr__nfet_01v8 ad=16.2 pd=17.4 as=16.2 ps=17.4 w=6 l=0.6
X7 out_p latch_sense_p tail vss sky130_fd_pr__nfet_01v8 ad=3.36 pd=8 as=3.12 ps=7.6 w=1.2 l=0.6
X8 iso_tail sense_n latch_sense_n vss sky130_fd_pr__nfet_01v8 ad=3.12 pd=7.6 as=3.36 ps=8 w=1.2 l=0.6
X9 vdd_active out_p out_n vdd_active sky130_fd_pr__pfet_01v8 ad=3.12 pd=7.6 as=3.36 ps=8 w=1.2 l=0.6
X10 latch_sense_p sense_p iso_tail vss sky130_fd_pr__nfet_01v8 ad=3.36 pd=8 as=3.12 ps=7.6 w=1.2 l=0.6
C0 latch_sense_p sense_p 0.22977f
C1 iso_tail latch_sense_n 0.20888f
C2 out_p out_n 2.54301f
C3 reset vdd 4.47121f
C4 tail out_n 0.46979f
C5 eval tail 0.35666f
C6 sense_n iso_tail 0.10725f
C7 latch_sense_p iso_tail 0.20888f
C8 reset out_p 0.376f
C9 out_p vdd_active 3.06556f
C10 reset tail 0.16491f
C11 tail vdd_active 0.9938f
C12 out_p vdd 0.76206f
C13 tail vdd 0.9918f
C14 tail latch_sense_n 0.0334f
C15 sense_n latch_sense_n 0.22977f
C16 iso_tail sense_p 0.26105f
C17 out_p tail 0.46979f
C18 out_p latch_sense_p 0.18428f
C19 latch_sense_p tail 0.0334f
C20 reset out_n 0.31048f
C21 vdd_active out_n 3.16716f
C22 vdd out_n 0.77104f
C23 latch_sense_n out_n 0.18428f
C24 iso_tail vss 29.23796f
C25 latch_sense_n vss 1.7693f
C26 latch_sense_p vss 1.56796f
C27 out_n vss 13.58747f
C28 tail vss 89.03816f
C29 vdd_active vss 90.11912f
C30 vdd vss 78.65506f
.ends

.subckt aimc_converter_macro_active_candidate vss vdd decision_p decision_n reset
+ eval vss_escape vdd_ext tail_ext
Xphysical_preamp_0 physical_preamp_0/iso_tail physical_preamp_0/iso_p physical_preamp_0/iso_n
+ physical_preamp_0/sense_p physical_preamp_0/sense_n physical_preamp_0/m1_3440_500#
+ vdd_ext vdd_ext vss_escape sky130_transistor_active_isolation_pair
Xconverter_latch_0 decision_p decision_n vdd_ext vdd_ext tail_ext reset vdd_ext vss_escape
+ eval vdd_ext vdd_ext vdd_ext vdd_ext escaped_input_latch
C0 decision_p tail_ext 0.01085f
C1 physical_preamp_0/iso_n physical_preamp_0/m1_3440_500# -0
C2 vdd_ext physical_preamp_0/iso_p 0.14232f
C3 vdd_ext physical_preamp_0/m1_3440_500# 0.00503f
C4 vdd_ext physical_preamp_0/iso_tail 0.63812f
C5 vdd_ext shared_converter_mux_0/vss 0.00313f
C6 decision_n tail_ext 0.01085f
C7 vss shared_converter_mux_0/vdd 0.2816f
C8 row_dac_10b_0/vss row_dac_10b_0/vdd 0.78467f
C9 shared_converter_mux_0/mux_bus shared_converter_mux_0/vdd 1.55306f
C10 vdd_ext row_dac_10b_0/vss 1.08123f
C11 vdd_ext eval 0
C12 vdd_ext vss 0.88561f
C13 vdd_ext shared_converter_mux_0/mux_bus 0.06497f
C14 vdd_ext reset 0.01669f
C15 shared_converter_mux_0/mux_bus shared_converter_mux_0/vss 1.56188f
C16 eval tail_ext 0.01085f
C17 vdd_ext physical_preamp_0/sense_n 0.03433f
C18 tail_ext reset 0.01085f
C19 vdd_ext decision_p 0
C20 vdd_ext shared_converter_mux_0/vdd 0.00313f
C21 shared_converter_mux_0/mux_bus vss 0.03132f
C22 vdd_ext row_dac_10b_0/vdd 1.11409f
C23 physical_preamp_0/sense_p vdd_ext 0.08225f
C24 vdd_ext physical_preamp_0/iso_n 0.10241f
C25 vdd vdd_ext 0.1964f
C26 vss vss_escape 36.7f
C27 vdd vss_escape 36.7f
C28 decision_n vss_escape 3.8093f
C29 eval vss_escape 0.78348f
C30 vdd_ext vss_escape 73.75104f
.ends
