* NGSPICE file created from aimc_converter_macro_active_candidate_flat_parallel.ext - technology: sky130A

.subckt aimc_converter_macro_active_candidate_flat_parallel vss vdd row_drive sar_comparator_input
+ decision_p decision_n reset eval vss_escape latch_sense_p_ext latch_sense_n_ext
+ iso_tail_ext tail_ext vdd_ext preamp_iso_tail_ext
X0 latch_sense_n_ext sar_comparator_input preamp_iso_tail_ext vss_escape sky130_fd_pr__nfet_01v8 ad=3.36 pd=8 as=3.12 ps=7.6 w=1.2 l=0.6
X1 latch_sense_p_ext row_drive preamp_iso_tail_ext vss_escape sky130_fd_pr__nfet_01v8 ad=3.36 pd=8 as=3.12 ps=7.6 w=1.2 l=0.6
X2 vdd_ext decision_p decision_n vdd_ext sky130_fd_pr__pfet_01v8 ad=3.12 pd=7.6 as=3.36 ps=8 w=1.2 l=0.6
X3 tail_ext eval vss_escape vss_escape sky130_fd_pr__nfet_01v8 ad=16.2 pd=17.4 as=16.2 ps=17.4 w=6 l=0.6
X4 latch_sense_n_ext sar_comparator_input preamp_iso_tail_ext vss_escape sky130_fd_pr__nfet_01v8 ad=3.36 pd=8 as=3.12 ps=7.6 w=1.2 l=0.6
X5 decision_p latch_sense_p_ext tail_ext vss_escape sky130_fd_pr__nfet_01v8 ad=3.36 pd=8 as=3.12 ps=7.6 w=1.2 l=0.6
X6 vdd_ext reset decision_n vdd_ext sky130_fd_pr__pfet_01v8 ad=3.12 pd=7.6 as=3.36 ps=8 w=1.2 l=0.6
X7 tail_ext latch_sense_n_ext decision_n vss_escape sky130_fd_pr__nfet_01v8 ad=3.12 pd=7.6 as=3.36 ps=8 w=1.2 l=0.6
X8 decision_p decision_n vdd_ext vdd_ext sky130_fd_pr__pfet_01v8 ad=3.36 pd=8 as=3.12 ps=7.6 w=1.2 l=0.6
X9 tail_ext decision_p decision_n vss_escape sky130_fd_pr__nfet_01v8 ad=3.12 pd=7.6 as=3.36 ps=8 w=1.2 l=0.6
X10 latch_sense_p_ext row_drive iso_tail_ext vss_escape sky130_fd_pr__nfet_01v8 ad=3.36 pd=8 as=3.12 ps=7.6 w=1.2 l=0.6
X11 iso_tail_ext sar_comparator_input latch_sense_n_ext vss_escape sky130_fd_pr__nfet_01v8 ad=3.12 pd=7.6 as=3.36 ps=8 w=1.2 l=0.6
X12 latch_sense_p_ext row_drive preamp_iso_tail_ext vss_escape sky130_fd_pr__nfet_01v8 ad=3.36 pd=8 as=3.12 ps=7.6 w=1.2 l=0.6
X13 decision_p reset vdd_ext vdd_ext sky130_fd_pr__pfet_01v8 ad=3.36 pd=8 as=3.12 ps=7.6 w=1.2 l=0.6
X14 decision_p decision_n tail_ext vss_escape sky130_fd_pr__nfet_01v8 ad=3.36 pd=8 as=3.12 ps=7.6 w=1.2 l=0.6
C0 vdd_ext shared_converter_mux_0.vss 0
C1 row_dac_10b_0.vss row_drive 1.08123f
C2 row_drive sar_comparator_input 5.53501f
C3 sar_readout_12b_0.vss row_drive 0.29433f
C4 latch_sense_n_ext sar_comparator_input 0.81129f
C5 iso_tail_ext latch_sense_p_ext 0.1295f
C6 latch_sense_p_ext preamp_iso_tail_ext 0.65876f
C7 shared_converter_mux_0.mux_bus vss 0.03132f
C8 reset latch_sense_p_ext 0.19529f
C9 m4_45060_36440# preamp_iso_tail_ext 0.00188f
C10 decision_n tail_ext 0.48065f
C11 reset decision_p 0.376f
C12 vdd_ext vss 0.19458f
C13 m1_68300_3080# row_drive 2.68328f
C14 row_dac_10b_0.vdd row_drive 1.11462f
C15 row_drive latch_sense_p_ext 1.41903f
C16 latch_sense_n_ext latch_sense_p_ext 0.69337f
C17 eval tail_ext 0.36751f
C18 row_drive m4_45060_36440# 0.10851f
C19 row_drive shared_converter_mux_0.vss 0.00246f
C20 shared_converter_mux_0.vdd vss 0.2816f
C21 vdd_ext decision_n 3.9382f
C22 m1_68300_3080# sar_comparator_input 0.05195f
C23 vdd_ext tail_ext 1.9856f
C24 row_dac_10b_0.vss row_dac_10b_0.vdd 0.78467f
C25 latch_sense_p_ext sar_comparator_input 0.11023f
C26 m4_45060_36440# sar_comparator_input 0.05954f
C27 vdd_ext eval 0
C28 vdd_ext shared_converter_mux_0.mux_bus 0.00217f
C29 row_drive vss 0.22445f
C30 vss latch_sense_n_ext 0.29037f
C31 reset decision_n 0.31048f
C32 reset tail_ext 0.17577f
C33 shared_converter_mux_0.vdd shared_converter_mux_0.mux_bus 1.55306f
C34 m4_45060_36440# latch_sense_p_ext 0.00631f
C35 decision_p latch_sense_p_ext 0.37635f
C36 vss sar_comparator_input 0.05708f
C37 vdd_ext shared_converter_mux_0.vdd 0
C38 decision_n latch_sense_n_ext 0.37635f
C39 vdd_ext iso_tail_ext 0.86179f
C40 tail_ext latch_sense_n_ext 1.09601f
C41 vdd_ext preamp_iso_tail_ext 0.06069f
C42 vdd_ext reset 4.48789f
C43 vdd_ext sar_readout_12b_0.vdd 1.39936f
C44 row_drive shared_converter_mux_0.mux_bus 0.06281f
C45 m4_32000_38940# latch_sense_n_ext 0.0096f
C46 decision_n sar_comparator_input 0.17131f
C47 vdd_ext row_drive 5.09496f
C48 vss latch_sense_p_ext 0.29037f
C49 vdd_ext latch_sense_n_ext 4.56493f
C50 sar_readout_12b_0.vdd iso_tail_ext 0.27521f
C51 row_drive m2_42000_41940# 0.12051f
C52 shared_converter_mux_0.vdd row_drive 0.00246f
C53 row_drive iso_tail_ext 2.39704f
C54 iso_tail_ext latch_sense_n_ext 0.12999f
C55 vdd_ext sar_comparator_input 1.7825f
C56 vdd_ext sar_readout_12b_0.vss 0.93663f
C57 tail_ext latch_sense_p_ext 0.99589f
C58 row_drive preamp_iso_tail_ext 0.25948f
C59 latch_sense_n_ext preamp_iso_tail_ext 0.66393f
C60 decision_n decision_p 2.54301f
C61 row_drive sar_readout_12b_0.vdd 0.58157f
C62 eval latch_sense_p_ext 0.19752f
C63 tail_ext decision_p 0.48065f
C64 iso_tail_ext sar_comparator_input 0.16721f
C65 sar_readout_12b_0.vss iso_tail_ext 0.60045f
C66 row_drive vdd 0.1964f
C67 m4_32000_38940# latch_sense_p_ext 0.00354f
C68 row_drive latch_sense_n_ext 0.84001f
C69 m1_68300_3080# vdd_ext 0.24419f
C70 preamp_iso_tail_ext sar_comparator_input 0.32843f
C71 vdd_ext latch_sense_p_ext 5.39204f
C72 shared_converter_mux_0.mux_bus shared_converter_mux_0.vss 1.56188f
C73 vdd_ext m4_45060_36440# 0.01404f
C74 sar_readout_12b_0.vss sar_readout_12b_0.vdd 0.49712f
C75 vdd_ext decision_p 3.8282f
C76 vss vss_escape 36.2394f
C77 vdd vss_escape 36.7f
C78 iso_tail_ext vss_escape 20.9682f
C79 decision_p vss_escape 20.52539f
C80 tail_ext vss_escape 0.1839p
C81 preamp_iso_tail_ext vss_escape 82.37074f
C82 vdd_ext vss_escape 0.26418p
C83 m4_45060_36440# vss_escape 0.07671f ; **FLOATING
C84 m4_32000_38940# vss_escape 0.1568f ; **FLOATING
C85 m2_42000_41940# vss_escape 3.91591f ; **FLOATING
C86 sar_readout_12b_0.vss vss_escape 1.33686f ; **FLOATING
C87 row_dac_10b_0.vss vss_escape 1.40333f ; **FLOATING
C88 row_dac_10b_0.vdd vss_escape 1.33457f ; **FLOATING
C89 sar_readout_12b_0.vdd vss_escape 1.77614f ; **FLOATING
C90 m1_68300_3080# vss_escape 7.89552f ; **FLOATING
C91 shared_converter_mux_0.vss vss_escape 1.39454f ; **FLOATING
C92 shared_converter_mux_0.mux_bus vss_escape 2.86922f ; **FLOATING
C93 shared_converter_mux_0.vdd vss_escape 0.95985f ; **FLOATING
.ends
