* NGSPICE file created from aimc_converter_macro_active_candidate.ext - technology: sky130A

.subckt escaped_input_latch out_p out_n latch_sense_p latch_sense_n tail reset vdd
+ vss eval sense_p sense_n iso_tail vdd_active
X0 out_p out_n vdd_active vdd_active sky130_fd_pr__pfet_01v8 ad=6.72 pd=10.4 as=6.24 ps=10 w=2.4 l=0.6
X1 vdd reset out_n vdd sky130_fd_pr__pfet_01v8 ad=3.12 pd=7.6 as=3.36 ps=8 w=1.2 l=0.6
X2 tail out_p out_n vss sky130_fd_pr__nfet_01v8 ad=12.48 pd=14.8 as=13.44 ps=15.2 w=4.8 l=0.6
X3 out_p reset vdd vdd sky130_fd_pr__pfet_01v8 ad=3.36 pd=8 as=3.12 ps=7.6 w=1.2 l=0.6
X4 out_p out_n tail vss sky130_fd_pr__nfet_01v8 ad=13.44 pd=15.2 as=12.48 ps=14.8 w=4.8 l=0.6
X5 tail latch_sense_n out_n vss sky130_fd_pr__nfet_01v8 ad=12.48 pd=14.8 as=13.44 ps=15.2 w=4.8 l=0.6
X6 tail eval vss vss sky130_fd_pr__nfet_01v8 ad=16.2 pd=17.4 as=16.2 ps=17.4 w=6 l=0.6
X7 out_p latch_sense_p tail vss sky130_fd_pr__nfet_01v8 ad=13.44 pd=15.2 as=12.48 ps=14.8 w=4.8 l=0.6
X8 iso_tail sense_n latch_sense_n vss sky130_fd_pr__nfet_01v8 ad=3.12 pd=7.6 as=3.36 ps=8 w=1.2 l=0.6
X9 vdd_active out_p out_n vdd_active sky130_fd_pr__pfet_01v8 ad=6.24 pd=10 as=6.72 ps=10.4 w=2.4 l=0.6
X10 latch_sense_p sense_p iso_tail vss sky130_fd_pr__nfet_01v8 ad=3.36 pd=8 as=3.12 ps=7.6 w=1.2 l=0.6
C0 out_p vdd_active 2.83065f
C1 vdd out_p 0.76206f
C2 out_n tail 0.51868f
C3 out_n latch_sense_n 0.1874f
C4 tail latch_sense_n 0.0334f
C5 reset out_p 0.376f
C6 sense_p latch_sense_p 0.22977f
C7 vdd reset 4.47121f
C8 latch_sense_p tail 0.0334f
C9 out_n out_p 2.60132f
C10 tail out_p 0.51868f
C11 sense_n latch_sense_n 0.22977f
C12 out_n vdd_active 2.93626f
C13 sense_p iso_tail 0.26105f
C14 tail eval 0.35666f
C15 vdd out_n 0.77104f
C16 tail vdd_active 0.9938f
C17 vdd tail 0.9918f
C18 latch_sense_n iso_tail 0.20888f
C19 latch_sense_p out_p 0.1874f
C20 out_n reset 0.31048f
C21 latch_sense_p iso_tail 0.20888f
C22 tail reset 0.16491f
C23 sense_n iso_tail 0.10725f
C24 iso_tail vss 29.23796f
C25 latch_sense_n vss 1.7693f
C26 latch_sense_p vss 1.56796f
C27 out_n vss 12.9274f
C28 tail vss 86.83939f
C29 vdd_active vss 89.13274f
C30 vdd vss 78.65506f
.ends

.subckt aimc_converter_macro_active_candidate vss vdd row_drive sar_comparator_input
+ decision_p decision_n reset eval vss_escape latch_sense_p_ext latch_sense_n_ext
+ iso_tail_ext tail_ext vdd_ext
Xconverter_latch_0 decision_p decision_n converter_latch_0/latch_sense_p converter_latch_0/latch_sense_n
+ converter_latch_0/tail reset vdd_ext vss_escape eval row_drive sar_comparator_input
+ converter_latch_0/iso_tail vdd_ext escaped_input_latch
C0 converter_latch_0/latch_sense_p row_drive 0
C1 shared_converter_mux_0/mux_bus vss 0.03132f
C2 reset vdd_ext 0.01669f
C3 row_drive row_dac_10b_0/vss 1.08123f
C4 row_drive vdd_ext 1.55835f
C5 eval converter_latch_0/tail 0.01085f
C6 row_dac_10b_0/vdd row_dac_10b_0/vss 0.78467f
C7 row_dac_10b_0/vdd row_drive 1.11409f
C8 converter_latch_0/latch_sense_p vss 0.23329f
C9 vdd_ext decision_p 0
C10 vdd_ext vss 0.19458f
C11 row_drive vss 0.22445f
C12 shared_converter_mux_0/mux_bus shared_converter_mux_0/vdd 1.55306f
C13 eval vdd_ext 0
C14 sar_readout_12b_0/vdd converter_latch_0/iso_tail 0.27625f
C15 shared_converter_mux_0/mux_bus shared_converter_mux_0/vss 1.56188f
C16 vdd_ext converter_latch_0/iso_tail 0.31557f
C17 sar_readout_12b_0/vss sar_readout_12b_0/vdd 0.49712f
C18 row_drive converter_latch_0/iso_tail 0.26323f
C19 decision_n converter_latch_0/tail 0.01085f
C20 shared_converter_mux_0/vdd vdd_ext 0
C21 shared_converter_mux_0/vdd row_drive 0.00246f
C22 sar_readout_12b_0/vss vdd_ext 0.93663f
C23 sar_readout_12b_0/vss row_drive 0.21493f
C24 shared_converter_mux_0/vss vdd_ext 0
C25 shared_converter_mux_0/vss row_drive 0.00246f
C26 shared_converter_mux_0/vdd vss 0.2816f
C27 vdd row_drive 0.1964f
C28 reset converter_latch_0/tail 0.01085f
C29 shared_converter_mux_0/mux_bus vdd_ext 0.00217f
C30 shared_converter_mux_0/mux_bus row_drive 0.06281f
C31 sar_comparator_input converter_latch_0/iso_tail 0.08712f
C32 converter_latch_0/latch_sense_n vss 0.23329f
C33 sar_readout_12b_0/vdd vdd_ext 1.39936f
C34 sar_readout_12b_0/vdd row_drive 0.33461f
C35 converter_latch_0/tail decision_p 0.01085f
C36 sar_readout_12b_0/vss converter_latch_0/iso_tail 0.60149f
C37 vss vss_escape 30.5941f
C38 vdd vss_escape 30.5941f
C39 sar_comparator_input vss_escape 1.15812f
C40 decision_n vss_escape 3.8093f
C41 eval vss_escape 0.78348f
C42 row_drive vss_escape 7.1806f
C43 vdd_ext vss_escape 34.16415f
.ends
