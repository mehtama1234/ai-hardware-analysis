* NGSPICE file created from aimc_converter_macro_active_candidate.ext - technology: sky130A

.subckt sky130_isolated_frontend_active_load_latch_v2 out_p out_n latch_sense_p latch_sense_n
+ tail reset vdd vss eval sense_p sense_n iso_tail vdd_active
X0 latch_sense_p sense_p iso_tail vss sky130_fd_pr__nfet_01v8 ad=3.36 pd=8 as=3.12 ps=7.6 w=1.2 l=0.6
X1 out_p out_n tail vss sky130_fd_pr__nfet_01v8 ad=3.36 pd=8 as=3.12 ps=7.6 w=1.2 l=0.6
X2 out_n latch_sense_n tail vss sky130_fd_pr__nfet_01v8 ad=3.36 pd=8 as=3.12 ps=7.6 w=1.2 l=0.6
X3 out_n out_p vdd_active vdd_active sky130_fd_pr__pfet_01v8 ad=3.36 pd=8 as=3.12 ps=7.6 w=1.2 l=0.6
X4 iso_tail sense_n latch_sense_n vss sky130_fd_pr__nfet_01v8 ad=3.12 pd=7.6 as=3.36 ps=8 w=1.2 l=0.6
X5 out_n out_p tail vss sky130_fd_pr__nfet_01v8 ad=3.36 pd=8 as=3.12 ps=7.6 w=1.2 l=0.6
X6 out_n reset vdd vdd sky130_fd_pr__pfet_01v8 ad=3.36 pd=8 as=3.12 ps=7.6 w=1.2 l=0.6
X7 out_p latch_sense_p tail vss sky130_fd_pr__nfet_01v8 ad=3.36 pd=8 as=3.12 ps=7.6 w=1.2 l=0.6
X8 tail eval vss vss sky130_fd_pr__nfet_01v8 ad=16.8 pd=17.6 as=15.6 ps=17.2 w=6 l=0.6
X9 out_p out_n vdd_active vdd_active sky130_fd_pr__pfet_01v8 ad=3.36 pd=8 as=3.12 ps=7.6 w=1.2 l=0.6
X10 out_p reset vdd vdd sky130_fd_pr__pfet_01v8 ad=3.36 pd=8 as=3.12 ps=7.6 w=1.2 l=0.6
C0 vdd_active latch_sense_n 0.53393f
C1 vdd out_p 1.0487f
C2 vdd out_n 0.95698f
C3 tail latch_sense_p 0.36163f
C4 latch_sense_n iso_tail 0.15122f
C5 out_p latch_sense_p 0.32159f
C6 latch_sense_p out_n 0.27084f
C7 m1_1000_12500# iso_tail 0.00302f
C8 vdd_active latch_sense_p 0.50449f
C9 iso_tail sense_n 0.11179f
C10 latch_sense_p iso_tail 0.09804f
C11 tail eval 0.09415f
C12 m1_1000_12500# sense_p 0.04904f
C13 reset out_p 0.07615f
C14 reset out_n 0.05967f
C15 out_p eval 0.04062f
C16 eval out_n 0.02298f
C17 m1_3440_12500# iso_tail 0.00302f
C18 latch_sense_p sense_p 0.06485f
C19 tail out_p 3.33055f
C20 tail out_n 2.28538f
C21 out_p out_n 1.85382f
C22 vdd_active out_p 4.31746f
C23 vdd_active out_n 5.52673f
C24 latch_sense_n sense_n 0.05507f
C25 latch_sense_p latch_sense_n 0.0207f
C26 m1_1000_12500# latch_sense_p 0.05106f
C27 iso_tail sense_p 0.12292f
C28 m1_3440_12500# latch_sense_n 0.0106f
C29 m1_3440_12500# sense_n 0.04904f
C30 tail latch_sense_n 0.4349f
C31 reset vdd 4.28849f
C32 out_p latch_sense_n 1.00043f
C33 out_n latch_sense_n 1.04924f
C34 tail vss 27.29601f
C35 out_p vss 12.23545f
C36 latch_sense_n vss 0.71261f
C37 iso_tail vss 4.24257f
C38 vdd vss 31.12f
C39 vdd_active vss 65.63497f
C40 m1_3440_12500# vss 0.33861f ; **FLOATING
C41 m1_1000_12500# vss 0.33861f ; **FLOATING
.ends

.subckt aimc_converter_macro_active_candidate vss vdd row_drive column_sense digital_code_out
Xconverter_latch_0 converter_latch_0/out_p converter_latch_0/out_n converter_latch_0/latch_sense_p
+ converter_latch_0/latch_sense_n vss converter_latch_0/reset converter_latch_0/vdd
+ vss converter_latch_0/eval converter_latch_0/sense_p converter_latch_0/sense_n converter_latch_0/iso_tail
+ converter_latch_0/vdd_active sky130_isolated_frontend_active_load_latch_v2
C0 sar_readout_12b_0/vdd sar_readout_12b_0/vss 0.53484f
C1 sar_readout_12b_0/vdd row_drive 0.00137f
C2 row_dac_10b_0/row_drive row_dac_10b_0/vdd 1.08417f
C3 row_drive shared_converter_mux_0/vss 0.00246f
C4 row_drive shared_converter_mux_0/mux_bus 0.06281f
C5 row_drive row_dac_10b_0/vss 0
C6 sar_readout_12b_0/sample_in sar_readout_12b_0/vdd 1.3202f
C7 row_dac_10b_0/vss row_dac_10b_0/vdd 0.78467f
C8 row_dac_10b_0/vss row_dac_10b_0/row_drive 1.07709f
C9 shared_converter_mux_0/vss shared_converter_mux_0/mux_bus 1.56188f
C10 converter_latch_0/out_p converter_latch_0/eval -0.00523f
C11 column_sense sar_readout_12b_0/vss 0
C12 row_drive shared_converter_mux_0/vdd 0.00246f
C13 digital_code_out vdd 0.1964f
C14 row_drive sar_readout_12b_0/vss 0.00137f
C15 column_sense vdd 0.1964f
C16 sar_readout_12b_0/sample_in column_sense 0
C17 sar_readout_12b_0/vdd column_sense 0.03336f
C18 row_drive row_dac_10b_0/vdd 0.01704f
C19 row_drive row_dac_10b_0/row_drive 0
C20 sar_readout_12b_0/sample_in sar_readout_12b_0/vss 1.05402f
C21 row_drive vdd 0.1964f
C22 shared_converter_mux_0/mux_bus shared_converter_mux_0/vdd 1.55306f
C23 sar_readout_12b_0/sample_in row_drive 0.03402f
C24 converter_latch_0/out_n converter_latch_0/eval -0.00131f
C25 digital_code_out vss 22.16245f
C26 column_sense vss 22.16245f
C27 row_drive vss 22.16245f
C28 vdd vss 22.6565f
C29 converter_latch_0/eval vss 0.05552f
C30 converter_latch_0/out_p vss 1.36292f
C31 converter_latch_0/out_n vss 0.6673f
C32 converter_latch_0/latch_sense_n vss 0.05384f
C33 converter_latch_0/latch_sense_p vss 0.0695f
C34 shared_converter_mux_0/mux_bus vss 0.03132f
C35 shared_converter_mux_0/vdd vss 0.2816f
.ends
