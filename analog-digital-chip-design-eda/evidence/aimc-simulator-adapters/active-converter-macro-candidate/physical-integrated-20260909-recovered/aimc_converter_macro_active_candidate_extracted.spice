* NGSPICE file created from aimc_converter_macro_active_candidate_flat.ext - technology: sky130A

.subckt aimc_converter_macro_active_candidate_flat vss vdd row_drive sar_comparator_input
+ decision_p decision_n reset eval vss_escape latch_sense_p_ext latch_sense_n_ext
+ iso_tail_ext tail_ext vdd_ext
X0 physical_preamp_0.iso_tail physical_preamp_0.sense_n physical_preamp_0.iso_n vss_escape sky130_fd_pr__nfet_01v8 ad=3.12 pd=7.6 as=3.36 ps=8 w=1.2 l=0.6
X1 vdd_ext decision_p decision_n vdd_ext sky130_fd_pr__pfet_01v8 ad=3.12 pd=7.6 as=3.36 ps=8 w=1.2 l=0.6
X2 tail_ext eval vss_escape vss_escape sky130_fd_pr__nfet_01v8 ad=16.2 pd=17.4 as=16.2 ps=17.4 w=6 l=0.6
X3 physical_preamp_0.iso_p physical_preamp_0.sense_p physical_preamp_0.iso_tail vss_escape sky130_fd_pr__nfet_01v8 ad=3.36 pd=8 as=3.12 ps=7.6 w=1.2 l=0.6
X4 decision_p latch_sense_p_ext tail_ext vss_escape sky130_fd_pr__nfet_01v8 ad=3.36 pd=8 as=3.12 ps=7.6 w=1.2 l=0.6
X5 vdd_ext reset decision_n vdd_ext sky130_fd_pr__pfet_01v8 ad=3.12 pd=7.6 as=3.36 ps=8 w=1.2 l=0.6
X6 tail_ext latch_sense_n_ext decision_n vss_escape sky130_fd_pr__nfet_01v8 ad=3.12 pd=7.6 as=3.36 ps=8 w=1.2 l=0.6
X7 decision_p decision_n vdd_ext vdd_ext sky130_fd_pr__pfet_01v8 ad=3.36 pd=8 as=3.12 ps=7.6 w=1.2 l=0.6
X8 tail_ext decision_p decision_n vss_escape sky130_fd_pr__nfet_01v8 ad=3.12 pd=7.6 as=3.36 ps=8 w=1.2 l=0.6
X9 latch_sense_p_ext row_drive iso_tail_ext vss_escape sky130_fd_pr__nfet_01v8 ad=3.36 pd=8 as=3.12 ps=7.6 w=1.2 l=0.6
X10 iso_tail_ext sar_comparator_input latch_sense_n_ext vss_escape sky130_fd_pr__nfet_01v8 ad=3.12 pd=7.6 as=3.36 ps=8 w=1.2 l=0.6
X11 decision_p reset vdd_ext vdd_ext sky130_fd_pr__pfet_01v8 ad=3.36 pd=8 as=3.12 ps=7.6 w=1.2 l=0.6
X12 decision_p decision_n tail_ext vss_escape sky130_fd_pr__nfet_01v8 ad=3.36 pd=8 as=3.12 ps=7.6 w=1.2 l=0.6
C0 decision_p reset 0.376f
C1 physical_preamp_0.iso_tail physical_preamp_0.iso_p 0.05749f
C2 m4_69940_3740# vss 0.00152f
C3 shared_converter_mux_0.vdd row_drive 0.00246f
C4 row_drive vdd_ext 2.69688f
C5 shared_converter_mux_0.mux_bus row_drive 0.06281f
C6 decision_n vdd_ext 3.9382f
C7 physical_preamp_0.sense_p row_drive 0.08156f
C8 sar_readout_12b_0.vss row_drive 0.29422f
C9 vss m1_68000_3740# 0.005f
C10 decision_p vdd_ext 3.8282f
C11 physical_preamp_0.sense_n vdd_ext 0.0039f
C12 shared_converter_mux_0.vss vdd_ext 0
C13 sar_comparator_input iso_tail_ext 0.16721f
C14 shared_converter_mux_0.mux_bus shared_converter_mux_0.vss 1.56188f
C15 vss latch_sense_p_ext 0.23329f
C16 m2_64900_1400# vdd_ext 0.07266f
C17 physical_preamp_0.sense_p m2_64900_1400# 0.03637f
C18 decision_n tail_ext 0.48065f
C19 sar_readout_12b_0.vdd row_drive 0.57218f
C20 latch_sense_p_ext iso_tail_ext 0.12577f
C21 row_drive latch_sense_n_ext 0.20099f
C22 decision_p tail_ext 0.48065f
C23 decision_n latch_sense_n_ext 0.18428f
C24 physical_preamp_0.iso_tail row_drive 0.02471f
C25 physical_preamp_0.iso_p row_drive 0.00133f
C26 m1_68000_3740# vdd_ext 0.008f
C27 sar_comparator_input vdd_ext 1.05718f
C28 physical_preamp_0.iso_n physical_preamp_0.sense_n 0.02157f
C29 physical_preamp_0.sense_p sar_comparator_input 0.04049f
C30 m2_64900_1400# physical_preamp_0.iso_n 0.41846f
C31 eval vdd_ext 0
C32 physical_preamp_0.sense_n physical_preamp_0.iso_tail 0.11179f
C33 latch_sense_p_ext vdd_ext 3.43095f
C34 shared_converter_mux_0.vdd vss 0.2816f
C35 vss vdd_ext 0.20794f
C36 shared_converter_mux_0.mux_bus vss 0.03132f
C37 m2_64900_1400# physical_preamp_0.iso_tail 0.34398f
C38 row_drive row_dac_10b_0.vss 1.08123f
C39 vdd row_drive 0.1964f
C40 m2_64900_1400# physical_preamp_0.iso_p 0.41846f
C41 iso_tail_ext vdd_ext 0.86179f
C42 physical_preamp_0.iso_n sar_comparator_input 0.0285f
C43 reset vdd_ext 4.48789f
C44 sar_readout_12b_0.vss iso_tail_ext 0.60045f
C45 sar_comparator_input latch_sense_n_ext 0.04279f
C46 m1_68000_3740# physical_preamp_0.iso_tail 0.00313f
C47 tail_ext eval 0.36751f
C48 sar_comparator_input physical_preamp_0.iso_tail 0.03759f
C49 latch_sense_p_ext tail_ext 0.0334f
C50 sar_comparator_input physical_preamp_0.iso_p 0.02717f
C51 shared_converter_mux_0.vdd vdd_ext 0
C52 shared_converter_mux_0.mux_bus shared_converter_mux_0.vdd 1.55306f
C53 shared_converter_mux_0.mux_bus vdd_ext 0.00217f
C54 vss latch_sense_n_ext 0.23329f
C55 physical_preamp_0.sense_p vdd_ext 0.03284f
C56 row_dac_10b_0.vdd row_dac_10b_0.vss 0.78467f
C57 reset tail_ext 0.17577f
C58 sar_readout_12b_0.vss vdd_ext 0.93663f
C59 sar_readout_12b_0.vdd iso_tail_ext 0.27521f
C60 decision_p decision_n 2.54301f
C61 iso_tail_ext latch_sense_n_ext 0.12577f
C62 shared_converter_mux_0.vss row_drive 0.00246f
C63 m2_64900_1400# row_drive 0.00382f
C64 row_drive row_dac_10b_0.vdd 1.11462f
C65 physical_preamp_0.iso_n vdd_ext 0.0106f
C66 tail_ext vdd_ext 1.9856f
C67 sar_readout_12b_0.vdd vdd_ext 1.39936f
C68 latch_sense_n_ext vdd_ext 3.48444f
C69 sar_readout_12b_0.vss sar_readout_12b_0.vdd 0.49712f
C70 m2_64900_1400# physical_preamp_0.sense_n 0.03955f
C71 physical_preamp_0.iso_tail vdd_ext 0.30577f
C72 sar_comparator_input row_drive 5.23145f
C73 physical_preamp_0.iso_p vdd_ext 0.02484f
C74 physical_preamp_0.sense_p physical_preamp_0.iso_tail 0.12292f
C75 physical_preamp_0.sense_p physical_preamp_0.iso_p 0.02157f
C76 latch_sense_p_ext row_drive 0.24412f
C77 vss row_drive 0.22445f
C78 sar_comparator_input physical_preamp_0.sense_n 0.07548f
C79 latch_sense_p_ext decision_p 0.18428f
C80 latch_sense_n_ext tail_ext 0.0334f
C81 row_drive iso_tail_ext 1.97962f
C82 m2_64900_1400# sar_comparator_input 0.1759f
C83 physical_preamp_0.iso_n physical_preamp_0.iso_tail 0.05717f
C84 physical_preamp_0.iso_n physical_preamp_0.iso_p 0.00782f
C85 decision_n reset 0.31048f
C86 vss vss_escape 36.2232f
C87 vdd vss_escape 36.7f
C88 iso_tail_ext vss_escape 55.47765f
C89 latch_sense_n_ext vss_escape 8.9128f
C90 latch_sense_p_ext vss_escape 24.51655f
C91 decision_p vss_escape 7.45999f
C92 tail_ext vss_escape 81.67176f
C93 vdd_ext vss_escape 0.2596p
C94 m4_69940_3740# vss_escape 0.08998f ; **FLOATING
C95 m2_64900_1400# vss_escape 0.72762f ; **FLOATING
C96 sar_readout_12b_0.vss vss_escape 1.33686f ; **FLOATING
C97 row_dac_10b_0.vss vss_escape 1.40333f ; **FLOATING
C98 row_dac_10b_0.vdd vss_escape 1.33457f ; **FLOATING
C99 sar_readout_12b_0.vdd vss_escape 1.77614f ; **FLOATING
C100 shared_converter_mux_0.vss vss_escape 1.39454f ; **FLOATING
C101 m1_68000_3740# vss_escape 0.35067f ; **FLOATING
C102 shared_converter_mux_0.mux_bus vss_escape 2.86922f ; **FLOATING
C103 shared_converter_mux_0.vdd vss_escape 0.95985f ; **FLOATING
C104 physical_preamp_0.iso_n vss_escape 1.04634f
C105 physical_preamp_0.iso_p vss_escape 1.04634f
C106 physical_preamp_0.iso_tail vss_escape 4.22827f
.ends
