* NGSPICE file created from aimc_converter_macro_active_candidate_flat.ext - technology: sky130A

.subckt aimc_converter_macro_active_candidate_flat vss vdd row_drive decision_p decision_n
+ reset eval vss_escape latch_sense_p_ext latch_sense_n_ext iso_tail_ext tail_ext
+ vdd_ext
X0 row_drive physical_preamp_0.sense_n physical_preamp_0.iso_n vss_escape sky130_fd_pr__nfet_01v8 ad=3.12 pd=7.6 as=3.36 ps=8 w=1.2 l=0.6
X1 vdd_ext decision_p decision_n vdd_ext sky130_fd_pr__pfet_01v8 ad=3.12 pd=7.6 as=3.36 ps=8 w=1.2 l=0.6
X2 tail_ext eval vss_escape vss_escape sky130_fd_pr__nfet_01v8 ad=16.2 pd=17.4 as=16.2 ps=17.4 w=6 l=0.6
X3 physical_preamp_0.iso_p physical_preamp_0.sense_p row_drive vss_escape sky130_fd_pr__nfet_01v8 ad=3.36 pd=8 as=3.12 ps=7.6 w=1.2 l=0.6
X4 decision_p latch_sense_p_ext tail_ext vss_escape sky130_fd_pr__nfet_01v8 ad=3.36 pd=8 as=3.12 ps=7.6 w=1.2 l=0.6
X5 vdd_ext reset decision_n vdd_ext sky130_fd_pr__pfet_01v8 ad=3.12 pd=7.6 as=3.36 ps=8 w=1.2 l=0.6
X6 tail_ext latch_sense_n_ext decision_n vss_escape sky130_fd_pr__nfet_01v8 ad=3.12 pd=7.6 as=3.36 ps=8 w=1.2 l=0.6
X7 decision_p decision_n vdd_ext vdd_ext sky130_fd_pr__pfet_01v8 ad=3.36 pd=8 as=3.12 ps=7.6 w=1.2 l=0.6
X8 tail_ext decision_p decision_n vss_escape sky130_fd_pr__nfet_01v8 ad=3.12 pd=7.6 as=3.36 ps=8 w=1.2 l=0.6
X9 latch_sense_p_ext row_drive iso_tail_ext vss_escape sky130_fd_pr__nfet_01v8 ad=3.36 pd=8 as=3.12 ps=7.6 w=1.2 l=0.6
X10 iso_tail_ext row_drive latch_sense_n_ext vss_escape sky130_fd_pr__nfet_01v8 ad=3.12 pd=7.6 as=3.36 ps=8 w=1.2 l=0.6
X11 decision_p reset vdd_ext vdd_ext sky130_fd_pr__pfet_01v8 ad=3.36 pd=8 as=3.12 ps=7.6 w=1.2 l=0.6
X12 decision_p decision_n tail_ext vss_escape sky130_fd_pr__nfet_01v8 ad=3.36 pd=8 as=3.12 ps=7.6 w=1.2 l=0.6
C0 row_dac_10b_0.vdd row_drive 1.11462f
C1 row_drive latch_sense_p_ext 0.6214f
C2 row_dac_10b_0.vss row_drive 1.08123f
C3 vdd_ext vss 0.21361f
C4 m3_42000_3080# physical_preamp_0.iso_p 0
C5 physical_preamp_0.iso_p vdd_ext 0.02433f
C6 shared_converter_mux_0.mux_bus shared_converter_mux_0.vdd 1.55306f
C7 m3_42000_3080# vdd_ext 0.56368f
C8 shared_converter_mux_0.vdd row_drive 0.00246f
C9 decision_p reset 0.376f
C10 reset vdd_ext 4.48789f
C11 vss latch_sense_n_ext 0.23329f
C12 shared_converter_mux_0.mux_bus row_drive 0.06281f
C13 decision_p vdd_ext 3.8282f
C14 sar_readout_12b_0.vdd row_drive 0.58157f
C15 physical_preamp_0.sense_p physical_preamp_0.iso_p 0.00681f
C16 physical_preamp_0.sense_p m3_42000_3080# 0
C17 physical_preamp_0.iso_n row_drive 0.53283f
C18 sar_readout_12b_0.vss vdd_ext 0.93663f
C19 li_67560_2680# row_drive 0.49309f
C20 physical_preamp_0.sense_p vdd_ext 0.00783f
C21 tail_ext eval 0.36751f
C22 vdd_ext latch_sense_n_ext 3.48444f
C23 physical_preamp_0.sense_n row_drive 0.34447f
C24 shared_converter_mux_0.vss vdd_ext 0
C25 reset decision_n 0.31048f
C26 vss latch_sense_p_ext 0.23329f
C27 decision_p decision_n 2.54301f
C28 physical_preamp_0.sense_n physical_preamp_0.iso_n 0.02157f
C29 physical_preamp_0.sense_n li_67560_2680# 0.10518f
C30 decision_n vdd_ext 3.9382f
C31 vdd_ext iso_tail_ext 0.86179f
C32 sar_readout_12b_0.vss iso_tail_ext 0.60045f
C33 shared_converter_mux_0.vdd vss 0.2816f
C34 decision_p latch_sense_p_ext 0.18428f
C35 shared_converter_mux_0.mux_bus vss 0.03132f
C36 vss row_drive 0.22445f
C37 vdd_ext latch_sense_p_ext 3.43095f
C38 decision_n latch_sense_n_ext 0.18428f
C39 reset tail_ext 0.17577f
C40 iso_tail_ext latch_sense_n_ext 0.12577f
C41 decision_p tail_ext 0.48065f
C42 vdd row_drive 0.1964f
C43 tail_ext vdd_ext 1.9856f
C44 physical_preamp_0.iso_p row_drive 0.55408f
C45 m3_42000_3080# row_drive 2.69526f
C46 shared_converter_mux_0.vdd vdd_ext 0
C47 shared_converter_mux_0.mux_bus vdd_ext 0.00217f
C48 physical_preamp_0.iso_p physical_preamp_0.iso_n 0.00782f
C49 sar_readout_12b_0.vdd vdd_ext 1.39936f
C50 vdd_ext row_drive 5.66178f
C51 m3_42000_3080# physical_preamp_0.iso_n 0
C52 m3_42000_3080# li_67560_2680# 0.03667f
C53 tail_ext latch_sense_n_ext 0.0334f
C54 sar_readout_12b_0.vss row_drive 0.29433f
C55 sar_readout_12b_0.vdd sar_readout_12b_0.vss 0.49712f
C56 physical_preamp_0.iso_n vdd_ext 0.0106f
C57 physical_preamp_0.sense_p row_drive 0.4161f
C58 iso_tail_ext latch_sense_p_ext 0.12577f
C59 li_67560_2680# vdd_ext 0.01099f
C60 physical_preamp_0.sense_n m3_42000_3080# 0
C61 decision_n tail_ext 0.48065f
C62 row_drive latch_sense_n_ext 0.62025f
C63 physical_preamp_0.sense_n vdd_ext 0.00811f
C64 shared_converter_mux_0.mux_bus shared_converter_mux_0.vss 1.56188f
C65 shared_converter_mux_0.vss row_drive 0.00246f
C66 row_dac_10b_0.vss row_dac_10b_0.vdd 0.78467f
C67 vdd_ext eval 0
C68 sar_readout_12b_0.vdd iso_tail_ext 0.27521f
C69 iso_tail_ext row_drive 2.56426f
C70 tail_ext latch_sense_p_ext 0.0334f
C71 vss vss_escape 36.2211f
C72 vdd vss_escape 36.7f
C73 iso_tail_ext vss_escape 69.14751f
C74 latch_sense_p_ext vss_escape 48.17932f
C75 decision_p vss_escape 7.38983f
C76 tail_ext vss_escape 81.08725f
C77 vdd_ext vss_escape 0.2587p
C78 m3_42000_3080# vss_escape 7.59003f ; **FLOATING
C79 sar_readout_12b_0.vss vss_escape 1.33686f ; **FLOATING
C80 row_dac_10b_0.vss vss_escape 1.40333f ; **FLOATING
C81 row_dac_10b_0.vdd vss_escape 1.33457f ; **FLOATING
C82 sar_readout_12b_0.vdd vss_escape 1.77614f ; **FLOATING
C83 shared_converter_mux_0.vss vss_escape 1.39454f ; **FLOATING
C84 shared_converter_mux_0.mux_bus vss_escape 2.86922f ; **FLOATING
C85 shared_converter_mux_0.vdd vss_escape 0.95985f ; **FLOATING
C86 li_67560_2680# vss_escape 1.56317f ; **FLOATING
C87 physical_preamp_0.iso_n vss_escape 1.18745f
C88 physical_preamp_0.iso_p vss_escape 1.00841f
.ends
