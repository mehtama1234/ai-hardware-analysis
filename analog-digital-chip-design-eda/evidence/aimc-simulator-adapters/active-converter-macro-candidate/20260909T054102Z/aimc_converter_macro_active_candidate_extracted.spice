* NGSPICE file created from aimc_converter_macro_active_candidate.ext - technology: sky130A

.subckt sky130_isolated_frontend_active_load_latch_v2 out_p out_n latch_sense_p latch_sense_n
+ tail reset vdd vss eval sense_p sense_n iso_tail vdd_active
X0 latch_sense_p sense_p iso_tail vss sky130_fd_pr__nfet_01v8 ad=3.36 pd=8 as=3.12 ps=7.6 w=1.2 l=0.6
X1 out_p out_n tail vss sky130_fd_pr__nfet_01v8 ad=3.36 pd=8 as=3.12 ps=7.6 w=1.2 l=0.6
X2 out_n latch_sense_n tail vss sky130_fd_pr__nfet_01v8 ad=3.36 pd=8 as=3.12 ps=7.6 w=1.2 l=0.6
X3 out_n out_p vdd_active vdd_active sky130_fd_pr__pfet_01v8 ad=3.36 pd=8 as=3.12 ps=7.6 w=1.2 l=0.6
X4 iso_tail sense_n latch_sense_n vss sky130_fd_pr__nfet_01v8 ad=3.12 pd=7.6 as=3.36 ps=8 w=1.2 l=0.6
X5 out_n out_p tail vss sky130_fd_pr__nfet_01v8 ad=3.36 pd=8 as=3.12 ps=7.6 w=1.2 l=0.6
X6 out_n reset vdd vdd sky130_fd_pr__pfet_01v8 ad=3.36 pd=8 as=3.12 ps=7.6 w=1.2 l=0.6
X7 out_p latch_sense_p tail vss sky130_fd_pr__nfet_01v8 ad=3.36 pd=8 as=3.12 ps=7.6 w=1.2 l=0.6
X8 tail eval vss vss sky130_fd_pr__nfet_01v8 ad=16.8 pd=17.6 as=15.6 ps=17.2 w=6 l=0.6
X9 out_p out_n vdd_active vdd_active sky130_fd_pr__pfet_01v8 ad=3.36 pd=8 as=3.12 ps=7.6 w=1.2 l=0.6
X10 out_p reset vdd vdd sky130_fd_pr__pfet_01v8 ad=3.36 pd=8 as=3.12 ps=7.6 w=1.2 l=0.6
C0 latch_sense_n tail 0.4349f
C1 sense_p m1_1000_12500# 0.04904f
C2 latch_sense_p out_n 0.27084f
C3 vdd reset 4.28849f
C4 out_p out_n 1.85382f
C5 eval tail 0.09415f
C6 latch_sense_n latch_sense_p 0.0207f
C7 iso_tail latch_sense_p 0.09804f
C8 latch_sense_p m1_1000_12500# 0.05106f
C9 sense_n latch_sense_n 0.05507f
C10 sense_n iso_tail 0.11179f
C11 vdd_active latch_sense_p 0.50449f
C12 sense_n m1_3440_12500# 0.04904f
C13 sense_p latch_sense_p 0.06485f
C14 latch_sense_n out_p 1.00043f
C15 latch_sense_p tail 0.36163f
C16 latch_sense_n out_n 1.04924f
C17 vdd_active out_p 4.31746f
C18 out_p reset 0.07615f
C19 out_p tail 3.33055f
C20 eval out_p 0.04062f
C21 vdd_active out_n 5.52673f
C22 out_n reset 0.05967f
C23 vdd out_p 1.0487f
C24 out_n tail 2.28538f
C25 eval out_n 0.02298f
C26 latch_sense_n iso_tail 0.15122f
C27 iso_tail m1_1000_12500# 0.00302f
C28 vdd out_n 0.95698f
C29 m1_3440_12500# latch_sense_n 0.0106f
C30 m1_3440_12500# iso_tail 0.00302f
C31 latch_sense_p out_p 0.32159f
C32 vdd_active latch_sense_n 0.53393f
C33 sense_p iso_tail 0.12292f
C34 tail vss 27.29601f
C35 out_p vss 12.23545f
C36 latch_sense_n vss 0.71261f
C37 iso_tail vss 4.24257f
C38 vdd vss 31.12f
C39 vdd_active vss 65.63497f
C40 m1_3440_12500# vss 0.33861f ; **FLOATING
C41 m1_1000_12500# vss 0.33861f ; **FLOATING
.ends

.subckt aimc_converter_macro_active_candidate vss vdd row_drive column_sense digital_code_out
Xconverter_latch_0 converter_latch_0/out_p converter_latch_0/out_n row_drive converter_latch_0/out_p
+ vss converter_latch_0/reset converter_latch_0/vdd vss converter_latch_0/eval converter_latch_0/sense_p
+ converter_latch_0/sense_n converter_latch_0/iso_tail converter_latch_0/vdd_active
+ sky130_isolated_frontend_active_load_latch_v2
C0 row_drive converter_latch_0/out_p 1.52184f
C1 row_dac_10b_0/vss row_dac_10b_0/vdd 0.78467f
C2 row_drive sar_readout_12b_0/vdd 0.29163f
C3 sar_readout_12b_0/vdd converter_latch_0/out_p 1.81378f
C4 row_drive vdd 0.1964f
C5 row_dac_10b_0/vss row_drive 1.08123f
C6 shared_converter_mux_0/vss shared_converter_mux_0/mux_bus 1.56188f
C7 sar_readout_12b_0/vss column_sense 0
C8 sar_readout_12b_0/vss row_drive 0.2347f
C9 sar_readout_12b_0/vss converter_latch_0/out_p 1.19054f
C10 sar_readout_12b_0/vss sar_readout_12b_0/vdd 0.53484f
C11 shared_converter_mux_0/vdd shared_converter_mux_0/mux_bus 1.55306f
C12 row_drive shared_converter_mux_0/vss 0.00246f
C13 converter_latch_0/out_n converter_latch_0/eval -0.00131f
C14 row_drive shared_converter_mux_0/mux_bus 0.06281f
C15 converter_latch_0/out_n converter_latch_0/out_p 0.04201f
C16 row_drive column_sense 0.14989f
C17 column_sense converter_latch_0/out_p 0.15526f
C18 digital_code_out vdd 0.1964f
C19 column_sense sar_readout_12b_0/vdd 0.03336f
C20 row_drive shared_converter_mux_0/vdd 0.00246f
C21 row_dac_10b_0/vdd row_drive 1.11409f
C22 column_sense vdd 0.1964f
C23 converter_latch_0/eval converter_latch_0/out_p -0.00523f
C24 digital_code_out vss 22.16245f
C25 column_sense vss 22.16245f
C26 vdd vss 22.6565f
C27 converter_latch_0/eval vss 0.05552f
C28 converter_latch_0/out_n vss 0.6673f
C29 row_drive vss 21.10843f
C30 converter_latch_0/out_p vss 4.03794f
C31 shared_converter_mux_0/mux_bus vss 0.03132f
C32 shared_converter_mux_0/vdd vss 0.2816f
.ends
