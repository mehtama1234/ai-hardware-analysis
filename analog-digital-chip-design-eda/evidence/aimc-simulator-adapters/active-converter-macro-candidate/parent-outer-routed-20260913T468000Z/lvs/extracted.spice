* NGSPICE file created from aimc_converter_macro_active_candidate_flat.ext - technology: sky130A

.subckt aimc_converter_macro_active_candidate_flat vss vdd row_drive sar_comparator_input
+ decision_p decision_n reset eval vss_escape latch_sense_p_ext latch_sense_n_ext
+ iso_tail_ext tail_ext vdd_ext
X0 physical_preamp_n.drain physical_preamp_n.gate preamp_iso_tail_ext vss_escape sky130_fd_pr__nfet_01v8 ad=3.36 pd=8 as=3.12 ps=7.6 w=1.2 l=0.6
X1 vdd_ext decision_p decision_n vdd_ext sky130_fd_pr__pfet_01v8 ad=3.12 pd=7.6 as=3.36 ps=8 w=1.2 l=0.6
X2 tail_ext eval vss_escape vss_escape sky130_fd_pr__nfet_01v8 ad=16.2 pd=17.4 as=16.2 ps=17.4 w=6 l=0.6
X3 decision_p latch_sense_p_ext tail_ext vss_escape sky130_fd_pr__nfet_01v8 ad=3.36 pd=8 as=3.12 ps=7.6 w=1.2 l=0.6
X4 vdd_ext reset decision_n vdd_ext sky130_fd_pr__pfet_01v8 ad=3.12 pd=7.6 as=3.36 ps=8 w=1.2 l=0.6
X5 tail_ext latch_sense_n_ext decision_n vss_escape sky130_fd_pr__nfet_01v8 ad=3.12 pd=7.6 as=3.36 ps=8 w=1.2 l=0.6
X6 decision_p decision_n vdd_ext vdd_ext sky130_fd_pr__pfet_01v8 ad=3.36 pd=8 as=3.12 ps=7.6 w=1.2 l=0.6
X7 tail_ext decision_p decision_n vss_escape sky130_fd_pr__nfet_01v8 ad=3.12 pd=7.6 as=3.36 ps=8 w=1.2 l=0.6
X8 latch_sense_p_ext row_drive iso_tail_ext vss_escape sky130_fd_pr__nfet_01v8 ad=3.36 pd=8 as=3.12 ps=7.6 w=1.2 l=0.6
X9 iso_tail_ext sar_comparator_input latch_sense_n_ext vss_escape sky130_fd_pr__nfet_01v8 ad=3.12 pd=7.6 as=3.36 ps=8 w=1.2 l=0.6
X10 physical_preamp_p.drain row_drive preamp_iso_tail_ext vss_escape sky130_fd_pr__nfet_01v8 ad=3.36 pd=8 as=3.12 ps=7.6 w=1.2 l=0.6
X11 decision_p reset vdd_ext vdd_ext sky130_fd_pr__pfet_01v8 ad=3.36 pd=8 as=3.12 ps=7.6 w=1.2 l=0.6
X12 decision_p decision_n tail_ext vss_escape sky130_fd_pr__nfet_01v8 ad=3.36 pd=8 as=3.12 ps=7.6 w=1.2 l=0.6
C0 preamp_iso_tail_ext physical_preamp_n.drain 0.09413f
C1 physical_preamp_n.gate row_drive 0.12269f
C2 row_dac_10b_0.vss row_drive 1.08123f
C3 decision_n tail_ext 0.48065f
C4 decision_n vdd_ext 3.9382f
C5 vss latch_sense_n_ext 0.29037f
C6 latch_sense_n_ext row_drive 0.65934f
C7 sar_comparator_input vdd_ext 1.06679f
C8 vdd row_drive 0.1964f
C9 m1_68300_3080# row_drive 2.68328f
C10 tail_ext vdd_ext 1.9856f
C11 shared_converter_mux_0.mux_bus shared_converter_mux_0.vdd 1.55306f
C12 physical_preamp_n.gate m4_51060_36440# 0.13059f
C13 physical_preamp_p.drain row_drive 0.08798f
C14 vss shared_converter_mux_0.vdd 0.2816f
C15 preamp_iso_tail_ext vdd_ext 0.16645f
C16 shared_converter_mux_0.vdd row_drive 0.00246f
C17 reset decision_n 0.31048f
C18 shared_converter_mux_0.vss vdd_ext 0
C19 latch_sense_n_ext iso_tail_ext 0.13015f
C20 sar_readout_12b_0.vss vdd_ext 0.93663f
C21 m4_8000_37340# vdd_ext 0.88127f
C22 sar_readout_12b_0.vdd vdd_ext 1.39936f
C23 row_drive row_dac_10b_0.vdd 1.11462f
C24 shared_converter_mux_0.mux_bus vdd_ext 0.00217f
C25 reset tail_ext 0.17577f
C26 reset vdd_ext 4.48789f
C27 decision_n decision_p 2.54301f
C28 sar_comparator_input row_drive 5.22878f
C29 physical_preamp_n.gate physical_preamp_n.drain 0.08798f
C30 vss vdd_ext 0.19458f
C31 sar_readout_12b_0.vss sar_readout_12b_0.vdd 0.49712f
C32 latch_sense_p_ext tail_ext 0.0334f
C33 row_drive vdd_ext 3.84053f
C34 shared_converter_mux_0.vss shared_converter_mux_0.mux_bus 1.56188f
C35 latch_sense_p_ext vdd_ext 3.4508f
C36 tail_ext decision_p 0.48065f
C37 decision_p vdd_ext 3.8282f
C38 m4_45060_36440# vdd_ext 0.01404f
C39 preamp_iso_tail_ext row_drive 0.44245f
C40 shared_converter_mux_0.vss row_drive 0.00246f
C41 row_dac_10b_0.vss row_dac_10b_0.vdd 0.78467f
C42 sar_comparator_input iso_tail_ext 0.16721f
C43 sar_readout_12b_0.vss row_drive 0.29433f
C44 m4_45060_36440# preamp_iso_tail_ext 0.04583f
C45 row_drive sar_readout_12b_0.vdd 0.58157f
C46 vss shared_converter_mux_0.mux_bus 0.03132f
C47 latch_sense_n_ext decision_n 0.36722f
C48 iso_tail_ext vdd_ext 0.86179f
C49 vdd_ext m4_51060_36440# 0.01404f
C50 shared_converter_mux_0.mux_bus row_drive 0.06281f
C51 physical_preamp_n.gate vdd_ext 0.01545f
C52 vss row_drive 0.22445f
C53 sar_comparator_input latch_sense_n_ext 0.0435f
C54 vss latch_sense_p_ext 0.23329f
C55 preamp_iso_tail_ext m4_51060_36440# 0.00179f
C56 reset decision_p 0.376f
C57 physical_preamp_n.gate preamp_iso_tail_ext 0.52866f
C58 latch_sense_n_ext tail_ext 0.93173f
C59 latch_sense_p_ext row_drive 0.62502f
C60 sar_readout_12b_0.vss iso_tail_ext 0.60045f
C61 latch_sense_n_ext vdd_ext 4.5405f
C62 iso_tail_ext sar_readout_12b_0.vdd 0.27521f
C63 m4_45060_36440# row_drive 0.13059f
C64 m1_68300_3080# vdd_ext 0.24419f
C65 tail_ext eval 0.36751f
C66 latch_sense_p_ext decision_p 0.18428f
C67 vdd_ext eval 0
C68 physical_preamp_p.drain vdd_ext 0.01216f
C69 physical_preamp_n.drain vdd_ext 0.01216f
C70 m4_8000_37340# latch_sense_n_ext 0.17431f
C71 shared_converter_mux_0.vdd vdd_ext 0
C72 iso_tail_ext row_drive 2.39704f
C73 preamp_iso_tail_ext physical_preamp_p.drain 0.09782f
C74 latch_sense_p_ext iso_tail_ext 0.12835f
C75 vss vss_escape 36.2394f
C76 vdd vss_escape 36.7f
C77 iso_tail_ext vss_escape 77.06784f
C78 latch_sense_n_ext vss_escape 9.0153f
C79 latch_sense_p_ext vss_escape 47.08435f
C80 decision_p vss_escape 8.30897f
C81 tail_ext vss_escape 91.16058f
C82 vdd_ext vss_escape 0.25846p
C83 m4_51060_36440# vss_escape 0.13014f ; **FLOATING
C84 m4_45060_36440# vss_escape 0.10814f ; **FLOATING
C85 m4_8000_37340# vss_escape 8.15017f ; **FLOATING
C86 sar_readout_12b_0.vss vss_escape 1.33686f ; **FLOATING
C87 row_dac_10b_0.vss vss_escape 1.40333f ; **FLOATING
C88 row_dac_10b_0.vdd vss_escape 1.33457f ; **FLOATING
C89 sar_readout_12b_0.vdd vss_escape 1.77614f ; **FLOATING
C90 m1_68300_3080# vss_escape 7.89552f ; **FLOATING
C91 shared_converter_mux_0.vss vss_escape 1.39454f ; **FLOATING
C92 shared_converter_mux_0.mux_bus vss_escape 2.86922f ; **FLOATING
C93 shared_converter_mux_0.vdd vss_escape 0.95985f ; **FLOATING
C94 physical_preamp_n.drain vss_escape 4.71732f
C95 physical_preamp_p.drain vss_escape 0.59096f
C96 preamp_iso_tail_ext vss_escape 16.61827f
.ends
