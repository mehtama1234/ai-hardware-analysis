* NGSPICE file created from aimc_converter_macro_active_candidate_flat.ext - technology: sky130A

.subckt aimc_converter_macro_active_candidate_flat vss vdd row_drive sar_comparator_input
+ decision_p decision_n reset eval vss_escape latch_sense_p_ext latch_sense_n_ext
+ iso_tail_ext tail_ext vdd_ext
X0 physical_preamp_0.iso_tail physical_preamp_0.sense_n physical_preamp_0.iso_n vss_escape sky130_fd_pr__nfet_01v8 ad=3.12 pd=7.6 as=3.36 ps=8 w=1.2 l=0.6
X1 vdd_ext decision_p decision_n vdd_ext sky130_fd_pr__pfet_01v8 ad=3.12 pd=7.6 as=3.36 ps=8 w=1.2 l=0.6
X2 tail_ext eval vss_escape vss_escape sky130_fd_pr__nfet_01v8 ad=16.2 pd=17.4 as=16.2 ps=17.4 w=6 l=0.6
X3 physical_preamp_0.iso_p physical_preamp_0.sense_p physical_preamp_0.iso_tail vss_escape sky130_fd_pr__nfet_01v8 ad=3.36 pd=8 as=3.12 ps=7.6 w=1.2 l=0.6
X4 decision_p latch_sense_p_ext tail_ext vss_escape sky130_fd_pr__nfet_01v8 ad=3.36 pd=8 as=3.12 ps=7.6 w=1.2 l=0.6
X5 vdd_ext reset decision_n vdd_ext sky130_fd_pr__pfet_01v8 ad=3.12 pd=7.6 as=3.36 ps=8 w=1.2 l=0.6
X6 tail_ext latch_sense_n_ext decision_n vss_escape sky130_fd_pr__nfet_01v8 ad=3.12 pd=7.6 as=3.36 ps=8 w=1.2 l=0.6
X7 decision_p decision_n vdd_ext vdd_ext sky130_fd_pr__pfet_01v8 ad=3.36 pd=8 as=3.12 ps=7.6 w=1.2 l=0.6
X8 tail_ext decision_p decision_n vss_escape sky130_fd_pr__nfet_01v8 ad=3.12 pd=7.6 as=3.36 ps=8 w=1.2 l=0.6
X9 latch_sense_p_ext row_drive iso_tail_ext vss_escape sky130_fd_pr__nfet_01v8 ad=3.36 pd=8 as=3.12 ps=7.6 w=1.2 l=0.6
X10 iso_tail_ext sar_comparator_input latch_sense_n_ext vss_escape sky130_fd_pr__nfet_01v8 ad=3.12 pd=7.6 as=3.36 ps=8 w=1.2 l=0.6
X11 decision_p reset vdd_ext vdd_ext sky130_fd_pr__pfet_01v8 ad=3.36 pd=8 as=3.12 ps=7.6 w=1.2 l=0.6
X12 decision_p decision_n tail_ext vss_escape sky130_fd_pr__nfet_01v8 ad=3.36 pd=8 as=3.12 ps=7.6 w=1.2 l=0.6
C0 vdd_ext tail_ext 1.9856f
C1 decision_p tail_ext 0.48065f
C2 vdd_ext latch_sense_n_ext 3.48444f
C3 sar_comparator_input row_drive 5.24644f
C4 vdd_ext physical_preamp_0.iso_p 0.01996f
C5 decision_n reset 0.31048f
C6 latch_sense_p_ext row_drive 0.6214f
C7 physical_preamp_0.iso_tail sar_comparator_input 0.03759f
C8 shared_converter_mux_0.vdd shared_converter_mux_0.mux_bus 1.55306f
C9 physical_preamp_0.iso_n physical_preamp_0.sense_n 0.02157f
C10 vdd_ext decision_p 3.8282f
C11 sar_readout_12b_0.vss iso_tail_ext 0.60045f
C12 m2_64900_1400# physical_preamp_0.iso_n 0.41846f
C13 physical_preamp_0.sense_n row_drive 0.09115f
C14 tail_ext eval 0.36751f
C15 shared_converter_mux_0.vss row_drive 0.00246f
C16 physical_preamp_0.sense_n physical_preamp_0.iso_tail 0.12781f
C17 li_67560_3080# physical_preamp_0.iso_p 0
C18 m2_64900_1400# row_drive 0.01775f
C19 physical_preamp_0.sense_p physical_preamp_0.iso_p 0.02157f
C20 m2_64900_1400# physical_preamp_0.iso_tail 0.34398f
C21 row_dac_10b_0.vdd row_drive 1.11462f
C22 vss latch_sense_p_ext 0.23329f
C23 li_67560_3080# vdd_ext 0.24419f
C24 vdd_ext eval 0
C25 shared_converter_mux_0.vdd vdd_ext 0
C26 physical_preamp_0.sense_p vdd_ext 0.03335f
C27 sar_readout_12b_0.vdd iso_tail_ext 0.27521f
C28 shared_converter_mux_0.mux_bus row_drive 0.06281f
C29 vdd_ext sar_readout_12b_0.vss 0.93663f
C30 iso_tail_ext row_drive 2.39704f
C31 reset tail_ext 0.17577f
C32 physical_preamp_0.iso_n physical_preamp_0.iso_p 0.00782f
C33 latch_sense_n_ext row_drive 0.57746f
C34 physical_preamp_0.iso_p row_drive 0.00627f
C35 physical_preamp_0.sense_p li_67560_3080# 0
C36 row_dac_10b_0.vdd row_dac_10b_0.vss 0.78467f
C37 physical_preamp_0.iso_n vdd_ext 0.00673f
C38 vdd_ext reset 4.48789f
C39 physical_preamp_0.iso_p physical_preamp_0.iso_tail 0.05749f
C40 decision_p reset 0.376f
C41 vdd_ext sar_readout_12b_0.vdd 1.39936f
C42 vdd row_drive 0.1964f
C43 vdd_ext row_drive 3.82785f
C44 physical_preamp_0.sense_n sar_comparator_input 0.07548f
C45 shared_converter_mux_0.mux_bus vss 0.03132f
C46 vdd_ext physical_preamp_0.iso_tail 0.18336f
C47 m2_64900_1400# sar_comparator_input 0.1759f
C48 li_67560_3080# physical_preamp_0.iso_n 0
C49 vss latch_sense_n_ext 0.23329f
C50 li_67560_3080# row_drive 2.7609f
C51 shared_converter_mux_0.vdd row_drive 0.00246f
C52 li_67560_3080# physical_preamp_0.iso_tail 0.00653f
C53 sar_readout_12b_0.vss sar_readout_12b_0.vdd 0.49712f
C54 physical_preamp_0.sense_p row_drive 0.19241f
C55 m2_64900_1400# physical_preamp_0.sense_n 0.04189f
C56 iso_tail_ext sar_comparator_input 0.16721f
C57 iso_tail_ext latch_sense_p_ext 0.12577f
C58 physical_preamp_0.sense_p physical_preamp_0.iso_tail 0.13895f
C59 sar_readout_12b_0.vss row_drive 0.29433f
C60 vdd_ext vss 0.19458f
C61 latch_sense_p_ext tail_ext 0.0334f
C62 latch_sense_n_ext sar_comparator_input 0.04279f
C63 physical_preamp_0.iso_p sar_comparator_input 0.02717f
C64 shared_converter_mux_0.vss shared_converter_mux_0.mux_bus 1.56188f
C65 decision_n tail_ext 0.48065f
C66 latch_sense_n_ext decision_n 0.18428f
C67 physical_preamp_0.iso_n row_drive 0.00494f
C68 vdd_ext sar_comparator_input 1.05659f
C69 physical_preamp_0.iso_n physical_preamp_0.iso_tail 0.05717f
C70 sar_readout_12b_0.vdd row_drive 0.58157f
C71 shared_converter_mux_0.vdd vss 0.2816f
C72 vdd_ext latch_sense_p_ext 3.43095f
C73 latch_sense_p_ext decision_p 0.18428f
C74 physical_preamp_0.iso_tail row_drive 0.38216f
C75 vdd_ext decision_n 3.9382f
C76 decision_n decision_p 2.54301f
C77 m2_64900_1400# physical_preamp_0.iso_p 0.41846f
C78 vdd_ext physical_preamp_0.sense_n 0.0031f
C79 vdd_ext shared_converter_mux_0.vss 0
C80 m2_64900_1400# vdd_ext 0.06307f
C81 physical_preamp_0.sense_p sar_comparator_input 0.04049f
C82 iso_tail_ext latch_sense_n_ext 0.12577f
C83 row_dac_10b_0.vss row_drive 1.08123f
C84 vss row_drive 0.22445f
C85 li_67560_3080# physical_preamp_0.sense_n 0.10132f
C86 vdd_ext shared_converter_mux_0.mux_bus 0.00217f
C87 latch_sense_n_ext tail_ext 0.0334f
C88 vdd_ext iso_tail_ext 0.86179f
C89 m2_64900_1400# li_67560_3080# 0
C90 physical_preamp_0.iso_n sar_comparator_input 0.0285f
C91 physical_preamp_0.sense_p m2_64900_1400# 0.03788f
C92 vss vss_escape 36.2394f
C93 vdd vss_escape 36.7f
C94 iso_tail_ext vss_escape 66.31805f
C95 latch_sense_n_ext vss_escape 8.9128f
C96 latch_sense_p_ext vss_escape 36.43705f
C97 decision_p vss_escape 7.38983f
C98 tail_ext vss_escape 81.08725f
C99 vdd_ext vss_escape 0.25709p
C100 m2_64900_1400# vss_escape 0.71003f ; **FLOATING
C101 sar_readout_12b_0.vss vss_escape 1.33686f ; **FLOATING
C102 row_dac_10b_0.vss vss_escape 1.40333f ; **FLOATING
C103 row_dac_10b_0.vdd vss_escape 1.33457f ; **FLOATING
C104 sar_readout_12b_0.vdd vss_escape 1.77614f ; **FLOATING
C105 shared_converter_mux_0.vss vss_escape 1.39454f ; **FLOATING
C106 shared_converter_mux_0.mux_bus vss_escape 2.86922f ; **FLOATING
C107 shared_converter_mux_0.vdd vss_escape 0.95985f ; **FLOATING
C108 li_67560_3080# vss_escape 8.20327f ; **FLOATING
C109 physical_preamp_0.iso_n vss_escape 1.39478f
C110 physical_preamp_0.iso_p vss_escape 1.22056f
C111 physical_preamp_0.iso_tail vss_escape 4.3757f
.ends
