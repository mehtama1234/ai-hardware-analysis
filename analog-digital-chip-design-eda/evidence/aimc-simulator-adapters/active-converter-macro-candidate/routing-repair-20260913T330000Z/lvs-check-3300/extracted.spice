* NGSPICE file created from aimc_converter_macro_active_candidate_flat.ext - technology: sky130A

.subckt aimc_converter_macro_active_candidate_flat vss vdd row_drive decision_p decision_n
+ reset eval vss_escape latch_sense_p_ext latch_sense_n_ext iso_tail_ext tail_ext
+ vdd_ext
X0 physical_preamp_0.preamp_iso_tail_ext vdd_ext physical_preamp_0.latch_sense_n_ext vss_escape sky130_fd_pr__nfet_01v8 ad=3.12 pd=7.6 as=3.36 ps=8 w=1.2 l=0.6
X1 vdd_ext decision_p decision_n vdd_ext sky130_fd_pr__pfet_01v8 ad=3.12 pd=7.6 as=3.36 ps=8 w=1.2 l=0.6
X2 tail_ext eval vss_escape vss_escape sky130_fd_pr__nfet_01v8 ad=16.2 pd=17.4 as=16.2 ps=17.4 w=6 l=0.6
X3 physical_preamp_0.latch_sense_p_ext row_drive physical_preamp_0.preamp_iso_tail_ext vss_escape sky130_fd_pr__nfet_01v8 ad=3.36 pd=8 as=3.12 ps=7.6 w=1.2 l=0.6
X4 decision_p latch_sense_p_ext tail_ext vss_escape sky130_fd_pr__nfet_01v8 ad=3.36 pd=8 as=3.12 ps=7.6 w=1.2 l=0.6
X5 vdd_ext reset decision_n vdd_ext sky130_fd_pr__pfet_01v8 ad=3.12 pd=7.6 as=3.36 ps=8 w=1.2 l=0.6
X6 tail_ext latch_sense_n_ext decision_n vss_escape sky130_fd_pr__nfet_01v8 ad=3.12 pd=7.6 as=3.36 ps=8 w=1.2 l=0.6
X7 decision_p decision_n vdd_ext vdd_ext sky130_fd_pr__pfet_01v8 ad=3.36 pd=8 as=3.12 ps=7.6 w=1.2 l=0.6
X8 tail_ext decision_p decision_n vss_escape sky130_fd_pr__nfet_01v8 ad=3.12 pd=7.6 as=3.36 ps=8 w=1.2 l=0.6
X9 latch_sense_p_ext row_drive iso_tail_ext vss_escape sky130_fd_pr__nfet_01v8 ad=3.36 pd=8 as=3.12 ps=7.6 w=1.2 l=0.6
X10 iso_tail_ext vdd_ext latch_sense_n_ext vss_escape sky130_fd_pr__nfet_01v8 ad=3.12 pd=7.6 as=3.36 ps=8 w=1.2 l=0.6
X11 decision_p reset vdd_ext vdd_ext sky130_fd_pr__pfet_01v8 ad=3.36 pd=8 as=3.12 ps=7.6 w=1.2 l=0.6
X12 decision_p decision_n tail_ext vss_escape sky130_fd_pr__nfet_01v8 ad=3.36 pd=8 as=3.12 ps=7.6 w=1.2 l=0.6
C0 decision_n tail_ext 0.48065f
C1 row_drive latch_sense_n_ext 0.57746f
C2 m1_68300_3080# row_drive 2.68356f
C3 row_dac_10b_0.vss row_dac_10b_0.vdd 0.78467f
C4 vdd_ext eval 0
C5 sar_readout_12b_0.vdd iso_tail_ext 0.27521f
C6 iso_tail_ext row_drive 2.39704f
C7 tail_ext latch_sense_p_ext 0.0334f
C8 row_dac_10b_0.vdd row_drive 1.11462f
C9 row_drive latch_sense_p_ext 0.6214f
C10 row_dac_10b_0.vss row_drive 1.08123f
C11 vdd_ext vss 0.19458f
C12 physical_preamp_0.preamp_iso_tail_ext row_drive 0.35829f
C13 m2_64900_1400# physical_preamp_0.latch_sense_n_ext 0.43369f
C14 physical_preamp_0.latch_sense_n_ext vdd_ext 0.10121f
C15 shared_converter_mux_0.vss shared_converter_mux_0.mux_bus 1.56188f
C16 m2_64900_1400# vdd_ext 0.33293f
C17 shared_converter_mux_0.mux_bus row_drive 0.06281f
C18 decision_p reset 0.376f
C19 reset vdd_ext 4.48789f
C20 vss latch_sense_n_ext 0.23329f
C21 shared_converter_mux_0.vss row_drive 0.00246f
C22 decision_p vdd_ext 3.8282f
C23 sar_readout_12b_0.vdd row_drive 0.58157f
C24 physical_preamp_0.latch_sense_p_ext physical_preamp_0.latch_sense_n_ext 0.01253f
C25 shared_converter_mux_0.mux_bus shared_converter_mux_0.vdd 1.55306f
C26 physical_preamp_0.latch_sense_p_ext m2_64900_1400# 0.43236f
C27 shared_converter_mux_0.vdd row_drive 0.00246f
C28 sar_readout_12b_0.vss vdd_ext 0.93663f
C29 physical_preamp_0.latch_sense_p_ext vdd_ext 0.08295f
C30 m1_68300_3080# physical_preamp_0.latch_sense_n_ext 0
C31 tail_ext eval 0.36751f
C32 m1_68300_3080# m2_64900_1400# 0
C33 vdd_ext latch_sense_n_ext 3.52723f
C34 m1_68300_3080# vdd_ext 0.24447f
C35 vss latch_sense_p_ext 0.23329f
C36 reset decision_n 0.31048f
C37 decision_p decision_n 2.54301f
C38 decision_n vdd_ext 3.9382f
C39 vdd_ext iso_tail_ext 1.029f
C40 physical_preamp_0.latch_sense_p_ext m1_68300_3080# 0
C41 sar_readout_12b_0.vss iso_tail_ext 0.60045f
C42 shared_converter_mux_0.mux_bus vss 0.03132f
C43 physical_preamp_0.preamp_iso_tail_ext physical_preamp_0.latch_sense_n_ext 0.07947f
C44 physical_preamp_0.preamp_iso_tail_ext m2_64900_1400# 0.34398f
C45 decision_p latch_sense_p_ext 0.18428f
C46 vss row_drive 0.22445f
C47 vdd_ext latch_sense_p_ext 3.43095f
C48 decision_n latch_sense_n_ext 0.18428f
C49 reset tail_ext 0.17577f
C50 iso_tail_ext latch_sense_n_ext 0.12577f
C51 physical_preamp_0.preamp_iso_tail_ext vdd_ext 0.36433f
C52 decision_p tail_ext 0.48065f
C53 vdd row_drive 0.1964f
C54 tail_ext vdd_ext 1.9856f
C55 shared_converter_mux_0.vdd vss 0.2816f
C56 physical_preamp_0.latch_sense_n_ext row_drive 0.00854f
C57 m2_64900_1400# row_drive 0.0495f
C58 physical_preamp_0.preamp_iso_tail_ext physical_preamp_0.latch_sense_p_ext 0.07124f
C59 shared_converter_mux_0.mux_bus vdd_ext 0.00217f
C60 shared_converter_mux_0.vss vdd_ext 0
C61 sar_readout_12b_0.vdd vdd_ext 1.39936f
C62 vdd_ext row_drive 11.7901f
C63 tail_ext latch_sense_n_ext 0.0334f
C64 physical_preamp_0.preamp_iso_tail_ext m1_68300_3080# 0.01748f
C65 sar_readout_12b_0.vdd sar_readout_12b_0.vss 0.49712f
C66 sar_readout_12b_0.vss row_drive 0.29433f
C67 shared_converter_mux_0.vdd vdd_ext 0
C68 physical_preamp_0.latch_sense_p_ext row_drive 0.03926f
C69 iso_tail_ext latch_sense_p_ext 0.12577f
C70 vss vss_escape 36.2292f
C71 vdd vss_escape 36.7f
C72 iso_tail_ext vss_escape 42.16421f
C73 latch_sense_n_ext vss_escape 21.19601f
C74 decision_p vss_escape 7.38983f
C75 tail_ext vss_escape 81.08725f
C76 m2_64900_1400# vss_escape 0.71263f ; **FLOATING
C77 sar_readout_12b_0.vss vss_escape 1.33686f ; **FLOATING
C78 row_dac_10b_0.vss vss_escape 1.40333f ; **FLOATING
C79 row_dac_10b_0.vdd vss_escape 1.33457f ; **FLOATING
C80 sar_readout_12b_0.vdd vss_escape 1.77614f ; **FLOATING
C81 m1_68300_3080# vss_escape 7.90194f ; **FLOATING
C82 shared_converter_mux_0.vss vss_escape 1.39454f ; **FLOATING
C83 shared_converter_mux_0.mux_bus vss_escape 2.86922f ; **FLOATING
C84 shared_converter_mux_0.vdd vss_escape 0.95985f ; **FLOATING
C85 physical_preamp_0.latch_sense_n_ext vss_escape 0.11961p
C86 physical_preamp_0.latch_sense_p_ext vss_escape 37.28456f
C87 physical_preamp_0.preamp_iso_tail_ext vss_escape 0.15868p
.ends
