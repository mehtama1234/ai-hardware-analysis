* NGSPICE file created from preamp_p_nfet.ext - technology: sky130A

.subckt preamp_p_nfet source drain gate body
X0 drain gate source body sky130_fd_pr__nfet_01v8 ad=3.36 pd=8 as=3.12 ps=7.6 w=1.2 l=0.6
.ends
