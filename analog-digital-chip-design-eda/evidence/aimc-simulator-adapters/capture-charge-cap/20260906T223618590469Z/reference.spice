* Independent two-terminal 2 um square MIM capacitor.
.subckt capture_charge_cap top bottom
XCAP top bottom sky130_fd_pr__cap_mim_m3_1 l=2 w=2
.ends capture_charge_cap
