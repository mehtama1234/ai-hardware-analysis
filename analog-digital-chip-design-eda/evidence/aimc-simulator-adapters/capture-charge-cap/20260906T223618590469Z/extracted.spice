* NGSPICE file created from capture_charge_cap.ext - technology: sky130A

.subckt capture_charge_cap top bottom
X0 top bottom sky130_fd_pr__cap_mim_m3_1 l=2 w=2
C0 bottom top 0.46782f
C1 top VSUBS 0.16967f
C2 bottom VSUBS 0.76275f
.ends
