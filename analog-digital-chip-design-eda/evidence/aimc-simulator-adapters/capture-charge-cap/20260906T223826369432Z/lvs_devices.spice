* NGSPICE file created from capture_charge_cap.ext - technology: sky130A

.subckt capture_charge_cap top bottom
X0 top bottom sky130_fd_pr__cap_mim_m3_1 l=2 w=2
.ends
