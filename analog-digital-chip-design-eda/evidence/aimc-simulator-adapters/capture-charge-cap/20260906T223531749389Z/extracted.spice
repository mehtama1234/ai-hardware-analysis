* NGSPICE file created from capture_charge_cap.ext - technology: sky130A

.subckt capture_charge_cap
X0 c1_n346_n200# m3_n386_n240# sky130_fd_pr__cap_mim_m3_1 l=2 w=2
C0 m3_n386_n240# c1_n346_n200# 0.46782f
C1 c1_n346_n200# VSUBS 0.16967f ; **FLOATING
C2 m3_n386_n240# VSUBS 0.76275f ; **FLOATING
.ends
