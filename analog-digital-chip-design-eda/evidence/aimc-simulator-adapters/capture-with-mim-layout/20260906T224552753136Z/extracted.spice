* NGSPICE file created from combined_latch_capture.ext - technology: sky130A

.subckt combined_latch_capture out_p out_n latch_sense_p latch_sense_n tail reset
+ vdd vss eval sense_p sense_n iso_tail vdd_active rx_p eq_reset capture_clk captured_q
X0 vss a_1634_36159# a_1592_36047# vss sky130_fd_pr__nfet_01v8 ad=0.12095 pd=1.085 as=0.0696 ps=0.765 w=0.42 l=0.15
X1 rx_p out_p vss vss sky130_fd_pr__nfet_01v8 ad=0.1218 pd=1.42 as=0.1218 ps=1.42 w=0.42 l=0.15
X2 a_1561_36413# a_1027_36047# vss vss sky130_fd_pr__pfet_01v8_hvt ad=0.07665 pd=0.785 as=0.06825 ps=0.745 w=0.42 l=0.15
X3 vss a_1634_36159# a_1561_36413# vss sky130_fd_pr__pfet_01v8_hvt ad=0.17887 pd=1.26 as=0.07665 ps=0.785 w=0.42 l=0.15
X4 a_1891_36413# a_1027_36047# a_1634_36159# vss sky130_fd_pr__pfet_01v8_hvt ad=0.0567 pd=0.69 as=0.1095 ps=1.075 w=0.42 l=0.15
X5 out_p out_n vdd_active vdd_active sky130_fd_pr__pfet_01v8 ad=6.72 pd=10.4 as=6.24 ps=10 w=2.4 l=0.6
X6 vss out_n vss vss sky130_fd_pr__nfet_01v8 ad=0.1218 pd=1.42 as=18.0388 ps=34.38 w=0.42 l=0.15
X7 vss a_1891_36413# a_2059_36315# vss sky130_fd_pr__nfet_01v8 ad=0.08775 pd=0.92 as=0.169 ps=1.82 w=0.65 l=0.15
X8 latch_sense_n eq_reset latch_sense_p vdd_active sky130_fd_pr__pfet_01v8 ad=3.24 pd=7.8 as=3.24 ps=7.8 w=1.2 l=0.6
X9 a_1975_36413# a_1193_36047# a_1891_36413# vss sky130_fd_pr__pfet_01v8_hvt ad=0.0882 pd=0.84 as=0.0567 ps=0.69 w=0.42 l=0.15
X10 vdd reset out_n vdd sky130_fd_pr__pfet_01v8 ad=3.12 pd=7.6 as=3.36 ps=8 w=1.2 l=0.6
X11 captured_q a_2059_36315# vss vss sky130_fd_pr__nfet_01v8 ad=0.169 pd=1.82 as=0.08775 ps=0.92 w=0.65 l=0.15
X12 tail out_p out_n vss sky130_fd_pr__nfet_01v8 ad=3.12 pd=7.6 as=3.36 ps=8 w=1.2 l=0.6
X13 vss vss sky130_fd_pr__cap_mim_m3_1 l=2 w=2
X14 a_1634_36159# vss vss vss sky130_fd_pr__pfet_01v8_hvt ad=0.1095 pd=1.075 as=0.17887 ps=1.26 w=0.75 l=0.15
X15 a_1891_36413# a_1193_36047# a_1634_36159# vss sky130_fd_pr__special_nfet_01v8 ad=0.0684 pd=0.74 as=0.0989 ps=0.995 w=0.36 l=0.15
X16 out_p reset vdd vdd sky130_fd_pr__pfet_01v8 ad=3.36 pd=8 as=3.12 ps=7.6 w=1.2 l=0.6
X17 vss vss sky130_fd_pr__cap_mim_m3_1 l=2 w=2
X18 a_2017_36047# a_1027_36047# a_1891_36413# vss sky130_fd_pr__special_nfet_01v8 ad=0.066 pd=0.745 as=0.0684 ps=0.74 w=0.36 l=0.15
X19 out_p out_n tail vss sky130_fd_pr__nfet_01v8 ad=3.36 pd=8 as=3.12 ps=7.6 w=1.2 l=0.6
X20 a_1381_36047# vss vss vss sky130_fd_pr__nfet_01v8 ad=0.0813 pd=0.83 as=0.1092 ps=1.36 w=0.42 l=0.15
X21 tail latch_sense_n out_n vss sky130_fd_pr__nfet_01v8 ad=3.12 pd=7.6 as=3.36 ps=8 w=1.2 l=0.6
X22 vss a_2059_36315# a_1975_36413# vss sky130_fd_pr__pfet_01v8_hvt ad=0.1113 pd=1.37 as=0.0882 ps=0.84 w=0.42 l=0.15
X23 tail eval vss vss sky130_fd_pr__nfet_01v8 ad=16.2 pd=17.4 as=16.2 ps=17.4 w=6 l=0.6
X24 a_1891_36413# vss sky130_fd_pr__cap_mim_m3_1 l=2 w=2
X25 vss a_1193_36047# a_1381_36047# vss sky130_fd_pr__pfet_01v8_hvt ad=0.06825 pd=0.745 as=0.05775 ps=0.695 w=0.42 l=0.15
X26 vss a_1027_36047# a_1381_36047# vss sky130_fd_pr__special_nfet_01v8 ad=0.0621 pd=0.705 as=0.0813 ps=0.83 w=0.36 l=0.15
X27 captured_q a_2059_36315# vss vss sky130_fd_pr__pfet_01v8_hvt ad=0.26 pd=2.52 as=0.135 ps=1.27 w=1 l=0.15
X28 vss a_1891_36413# a_2059_36315# vss sky130_fd_pr__pfet_01v8_hvt ad=0.135 pd=1.27 as=0.27 ps=2.54 w=1 l=0.15
X29 a_1891_36413# vss sky130_fd_pr__cap_mim_m3_1 l=2 w=2
X30 out_p latch_sense_p tail vss sky130_fd_pr__nfet_01v8 ad=3.36 pd=8 as=3.12 ps=7.6 w=1.2 l=0.6
X31 a_1381_36047# vss vss vss sky130_fd_pr__pfet_01v8_hvt ad=0.05775 pd=0.695 as=0.1092 ps=1.36 w=0.42 l=0.15
X32 a_1634_36159# vss vss vss sky130_fd_pr__nfet_01v8 ad=0.0989 pd=0.995 as=0.12095 ps=1.085 w=0.64 l=0.15
X33 vss a_2059_36315# a_2017_36047# vss sky130_fd_pr__nfet_01v8 ad=0.1092 pd=1.36 as=0.066 ps=0.745 w=0.42 l=0.15
X34 iso_tail sense_n latch_sense_n vss sky130_fd_pr__nfet_01v8 ad=3.12 pd=7.6 as=3.36 ps=8 w=1.2 l=0.6
X35 rx_p out_p vdd_active vdd_active sky130_fd_pr__pfet_01v8 ad=0.1218 pd=1.42 as=0.1218 ps=1.42 w=0.42 l=0.15
X36 a_1193_36047# a_1027_36047# vss vss sky130_fd_pr__pfet_01v8_hvt ad=0.1664 pd=1.8 as=0.0864 ps=0.91 w=0.64 l=0.15
X37 a_1592_36047# a_1193_36047# vss vss sky130_fd_pr__special_nfet_01v8 ad=0.0696 pd=0.765 as=0.0621 ps=0.705 w=0.36 l=0.15
X38 vdd_active out_n vss vdd_active sky130_fd_pr__pfet_01v8 ad=0.1218 pd=1.42 as=0.1218 ps=1.42 w=0.42 l=0.15
X39 vss capture_clk a_1027_36047# vss sky130_fd_pr__pfet_01v8_hvt ad=0.0864 pd=0.91 as=0.1664 ps=1.8 w=0.64 l=0.15
X40 a_1193_36047# a_1027_36047# vss vss sky130_fd_pr__nfet_01v8 ad=0.1092 pd=1.36 as=0.0567 ps=0.69 w=0.42 l=0.15
X41 vss capture_clk a_1027_36047# vss sky130_fd_pr__nfet_01v8 ad=0.0567 pd=0.69 as=0.1092 ps=1.36 w=0.42 l=0.15
X42 vdd_active out_p out_n vdd_active sky130_fd_pr__pfet_01v8 ad=6.24 pd=10 as=6.72 ps=10.4 w=2.4 l=0.6
X43 latch_sense_p sense_p iso_tail vss sky130_fd_pr__nfet_01v8 ad=3.36 pd=8 as=3.12 ps=7.6 w=1.2 l=0.6
C0 out_p reset 0.31048f
C1 a_1891_36413# captured_q 0.02036f
C2 out_n reset 0.31048f
C3 a_1634_36159# a_2059_36315# 0
C4 vdd_active latch_sense_p 0.91317f
C5 a_1634_36159# a_1891_36413# 0.03527f
C6 a_1975_36413# a_1193_36047# 0
C7 captured_q capture_clk 0
C8 captured_q a_1193_36047# 0
C9 latch_sense_n latch_sense_p 0.05388f
C10 a_1634_36159# a_1193_36047# 0.08345f
C11 a_1027_36047# a_1561_36413# 0.00168f
C12 vdd_active eq_reset 1.50445f
C13 a_1891_36413# tail 0
C14 sense_p latch_sense_p 0.02861f
C15 a_1027_36047# captured_q 0
C16 a_1381_36047# a_1561_36413# 0.00138f
C17 eq_reset latch_sense_n 0.02611f
C18 a_1634_36159# a_1027_36047# 0.09081f
C19 a_2059_36315# a_1891_36413# 0.2331f
C20 a_1381_36047# captured_q 0
C21 a_1592_36047# captured_q 0
C22 out_p tail 0.18071f
C23 out_n tail 0.18071f
C24 eval tail 0.09536f
C25 a_1634_36159# a_1381_36047# 0
C26 a_1634_36159# a_1592_36047# 0
C27 sense_n iso_tail 0.03465f
C28 vdd reset 4.03064f
C29 vdd_active tail 1.43419f
C30 a_2059_36315# a_1193_36047# 0.01914f
C31 a_1891_36413# a_1193_36047# 0.12616f
C32 tail latch_sense_n 0.0334f
C33 eq_reset latch_sense_p 0.02611f
C34 capture_clk a_1193_36047# 0.00591f
C35 a_2059_36315# a_1027_36047# 0.02545f
C36 a_1027_36047# a_1891_36413# 0.04078f
C37 out_n out_p 2.57005f
C38 iso_tail latch_sense_n 0.07366f
C39 a_1027_36047# capture_clk 0.15126f
C40 a_2017_36047# captured_q 0
C41 sense_n latch_sense_n 0.02861f
C42 a_1027_36047# a_1193_36047# 0.56916f
C43 out_p vdd_active 3.44635f
C44 out_n vdd_active 3.49958f
C45 tail latch_sense_p 0.0334f
C46 a_1634_36159# a_1975_36413# 0.0012f
C47 vdd tail 0.94872f
C48 a_1634_36159# a_2017_36047# 0
C49 iso_tail sense_p 0.03465f
C50 a_1634_36159# captured_q 0
C51 a_1381_36047# a_1193_36047# 0.06685f
C52 a_1592_36047# a_1193_36047# 0
C53 out_n latch_sense_n 0.15098f
C54 vdd_active latch_sense_n 1.17466f
C55 out_p rx_p 0.05225f
C56 iso_tail latch_sense_p 0.07366f
C57 out_n rx_p 0
C58 a_1027_36047# a_1381_36047# 0.04548f
C59 rx_p vdd_active 0.14036f
C60 a_2059_36315# a_2017_36047# 0
C61 out_p latch_sense_p 0.15098f
C62 vdd out_p 0.76206f
C63 a_2059_36315# captured_q 0.06507f
C64 a_1975_36413# a_1891_36413# 0.01219f
C65 out_n vdd 0.76206f
C66 a_2017_36047# a_1891_36413# 0.00937f
C67 iso_tail vss 21.8637f
C68 sense_n vss 1.81302f
C69 sense_p vss 1.81302f
C70 eq_reset vss 0.42287f
C71 latch_sense_n vss 7.80027f
C72 latch_sense_p vss 8.19727f
C73 rx_p vss 0.78388f
C74 out_n vss 21.5739f
C75 out_p vss 21.5804f
C76 reset vss 5.54678f
C77 tail vss 42.0697f
C78 eval vss 1.0217f
C79 captured_q vss 0.44427f
C80 capture_clk vss 0.52912f
C81 vdd_active vss 0.12615p
C82 vdd vss 69.8671f
C83 a_2017_36047# vss 0.0039f ; **FLOATING
C84 a_1592_36047# vss 0.01472f ; **FLOATING
C85 a_1975_36413# vss 0.0042f ; **FLOATING
C86 a_1561_36413# vss 0.01408f ; **FLOATING
C87 a_1381_36047# vss 0.22508f ; **FLOATING
C88 a_1891_36413# vss 4.17365f ; **FLOATING
C89 a_2059_36315# vss 0.60222f ; **FLOATING
C90 a_1634_36159# vss 0.5257f ; **FLOATING
C91 a_1193_36047# vss 0.86201f ; **FLOATING
C92 a_1027_36047# vss 1.20113f ; **FLOATING
.ends
