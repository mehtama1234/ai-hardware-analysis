* NGSPICE file created from combined_latch_capture.ext - technology: sky130A

.subckt combined_latch_capture out_p out_n latch_sense_p latch_sense_n tail reset
+ vdd vss eval sense_p sense_n iso_tail vdd_active rx_p rx_n eq_reset capture_clk
+ captured_q vdd_capture
X0 vss a_1634_36159# a_1592_36047# vss sky130_fd_pr__nfet_01v8 ad=0.12095 pd=1.085 as=0.0696 ps=0.765 w=0.42 l=0.15
X1 rx_p out_p vss vss sky130_fd_pr__nfet_01v8 ad=0.1218 pd=1.42 as=0.1218 ps=1.42 w=0.42 l=0.15
X2 a_1561_36413# a_1027_36047# rx_n vdd_capture sky130_fd_pr__pfet_01v8_hvt ad=0.07665 pd=0.785 as=0.06825 ps=0.745 w=0.42 l=0.15
X3 vdd_capture a_1634_36159# a_1561_36413# vdd_capture sky130_fd_pr__pfet_01v8_hvt ad=0.17887 pd=1.26 as=0.07665 ps=0.785 w=0.42 l=0.15
X4 a_1891_36413# a_1027_36047# a_1634_36159# vdd_capture sky130_fd_pr__pfet_01v8_hvt ad=0.0567 pd=0.69 as=0.1095 ps=1.075 w=0.42 l=0.15
X5 out_p out_n vdd_active vdd_active sky130_fd_pr__pfet_01v8 ad=6.72 pd=10.4 as=6.24 ps=10 w=2.4 l=0.6
X6 vss out_n rx_n vss sky130_fd_pr__nfet_01v8 ad=0.1218 pd=1.42 as=0.1218 ps=1.42 w=0.42 l=0.15
X7 vss a_1891_36413# a_2059_36315# vss sky130_fd_pr__nfet_01v8 ad=0.08775 pd=0.92 as=0.169 ps=1.82 w=0.65 l=0.15
X8 latch_sense_n eq_reset latch_sense_p vdd_active sky130_fd_pr__pfet_01v8 ad=3.24 pd=7.8 as=3.24 ps=7.8 w=1.2 l=0.6
X9 a_1975_36413# a_1193_36047# a_1891_36413# vdd_capture sky130_fd_pr__pfet_01v8_hvt ad=0.0882 pd=0.84 as=0.0567 ps=0.69 w=0.42 l=0.15
X10 vdd reset out_n vdd sky130_fd_pr__pfet_01v8 ad=3.12 pd=7.6 as=3.36 ps=8 w=1.2 l=0.6
X11 captured_q a_2059_36315# vss vss sky130_fd_pr__nfet_01v8 ad=0.169 pd=1.82 as=0.08775 ps=0.92 w=0.65 l=0.15
X12 tail out_p out_n vss sky130_fd_pr__nfet_01v8 ad=3.12 pd=7.6 as=3.36 ps=8 w=1.2 l=0.6
X13 rx_n vss sky130_fd_pr__cap_mim_m3_1 l=2 w=2
X14 a_1634_36159# rx_n vdd_capture vdd_capture sky130_fd_pr__pfet_01v8_hvt ad=0.1095 pd=1.075 as=0.17887 ps=1.26 w=0.75 l=0.15
X15 a_1891_36413# a_1193_36047# a_1634_36159# vss sky130_fd_pr__special_nfet_01v8 ad=0.0684 pd=0.74 as=0.0989 ps=0.995 w=0.36 l=0.15
X16 out_p reset vdd vdd sky130_fd_pr__pfet_01v8 ad=3.36 pd=8 as=3.12 ps=7.6 w=1.2 l=0.6
X17 rx_n vdd_capture sky130_fd_pr__cap_mim_m3_1 l=2 w=2
X18 a_2017_36047# a_1027_36047# a_1891_36413# vss sky130_fd_pr__special_nfet_01v8 ad=0.066 pd=0.745 as=0.0684 ps=0.74 w=0.36 l=0.15
X19 out_p out_n tail vss sky130_fd_pr__nfet_01v8 ad=3.36 pd=8 as=3.12 ps=7.6 w=1.2 l=0.6
X20 a_1381_36047# rx_n vss vss sky130_fd_pr__nfet_01v8 ad=0.0813 pd=0.83 as=0.1092 ps=1.36 w=0.42 l=0.15
X21 tail latch_sense_n out_n vss sky130_fd_pr__nfet_01v8 ad=3.12 pd=7.6 as=3.36 ps=8 w=1.2 l=0.6
X22 vdd_capture a_2059_36315# a_1975_36413# vdd_capture sky130_fd_pr__pfet_01v8_hvt ad=0.1113 pd=1.37 as=0.0882 ps=0.84 w=0.42 l=0.15
X23 tail eval vss vss sky130_fd_pr__nfet_01v8 ad=16.2 pd=17.4 as=16.2 ps=17.4 w=6 l=0.6
X24 a_1891_36413# vss sky130_fd_pr__cap_mim_m3_1 l=2 w=2
X25 rx_n a_1193_36047# a_1381_36047# vdd_capture sky130_fd_pr__pfet_01v8_hvt ad=0.06825 pd=0.745 as=0.05775 ps=0.695 w=0.42 l=0.15
X26 rx_n a_1027_36047# a_1381_36047# vss sky130_fd_pr__special_nfet_01v8 ad=0.0621 pd=0.705 as=0.0813 ps=0.83 w=0.36 l=0.15
X27 captured_q a_2059_36315# vdd_capture vdd_capture sky130_fd_pr__pfet_01v8_hvt ad=0.26 pd=2.52 as=0.135 ps=1.27 w=1 l=0.15
X28 vdd_capture a_1891_36413# a_2059_36315# vdd_capture sky130_fd_pr__pfet_01v8_hvt ad=0.135 pd=1.27 as=0.27 ps=2.54 w=1 l=0.15
X29 a_1891_36413# vdd_capture sky130_fd_pr__cap_mim_m3_1 l=2 w=2
X30 out_p latch_sense_p tail vss sky130_fd_pr__nfet_01v8 ad=3.36 pd=8 as=3.12 ps=7.6 w=1.2 l=0.6
X31 a_1381_36047# rx_n vdd_capture vdd_capture sky130_fd_pr__pfet_01v8_hvt ad=0.05775 pd=0.695 as=0.1092 ps=1.36 w=0.42 l=0.15
X32 a_1634_36159# rx_n vss vss sky130_fd_pr__nfet_01v8 ad=0.0989 pd=0.995 as=0.12095 ps=1.085 w=0.64 l=0.15
X33 vss a_2059_36315# a_2017_36047# vss sky130_fd_pr__nfet_01v8 ad=0.1092 pd=1.36 as=0.066 ps=0.745 w=0.42 l=0.15
X34 iso_tail sense_n latch_sense_n vss sky130_fd_pr__nfet_01v8 ad=3.12 pd=7.6 as=3.36 ps=8 w=1.2 l=0.6
X35 rx_p out_p vdd_active vdd_active sky130_fd_pr__pfet_01v8 ad=0.1218 pd=1.42 as=0.1218 ps=1.42 w=0.42 l=0.15
X36 a_1193_36047# a_1027_36047# vdd_capture vdd_capture sky130_fd_pr__pfet_01v8_hvt ad=0.1664 pd=1.8 as=0.0864 ps=0.91 w=0.64 l=0.15
X37 a_1592_36047# a_1193_36047# rx_n vss sky130_fd_pr__special_nfet_01v8 ad=0.0696 pd=0.765 as=0.0621 ps=0.705 w=0.36 l=0.15
X38 vdd_active out_n rx_n vdd_active sky130_fd_pr__pfet_01v8 ad=0.1218 pd=1.42 as=0.1218 ps=1.42 w=0.42 l=0.15
X39 vdd_capture capture_clk a_1027_36047# vdd_capture sky130_fd_pr__pfet_01v8_hvt ad=0.0864 pd=0.91 as=0.1664 ps=1.8 w=0.64 l=0.15
X40 a_1193_36047# a_1027_36047# vss vss sky130_fd_pr__nfet_01v8 ad=0.1092 pd=1.36 as=0.0567 ps=0.69 w=0.42 l=0.15
X41 vss capture_clk a_1027_36047# vss sky130_fd_pr__nfet_01v8 ad=0.0567 pd=0.69 as=0.1092 ps=1.36 w=0.42 l=0.15
X42 vdd_active out_p out_n vdd_active sky130_fd_pr__pfet_01v8 ad=6.24 pd=10 as=6.72 ps=10.4 w=2.4 l=0.6
X43 latch_sense_p sense_p iso_tail vss sky130_fd_pr__nfet_01v8 ad=3.36 pd=8 as=3.12 ps=7.6 w=1.2 l=0.6
C0 a_1193_36047# a_2059_36315# 0.01914f
C1 eq_reset latch_sense_n 0.02611f
C2 a_2059_36315# a_1634_36159# 0
C3 vdd out_n 0.76206f
C4 latch_sense_p out_p 0.15098f
C5 a_1027_36047# a_1891_36413# 0.04078f
C6 eq_reset latch_sense_p 0.02611f
C7 a_1027_36047# a_1381_36047# 0.04548f
C8 tail latch_sense_n 0.0334f
C9 rx_n capture_clk 0.0153f
C10 a_2059_36315# vdd_capture 0.32086f
C11 a_1561_36413# vdd_capture 0.00299f
C12 tail latch_sense_p 0.0334f
C13 captured_q a_2059_36315# 0.06507f
C14 vdd_active out_p 3.44635f
C15 eq_reset vdd_active 1.50445f
C16 a_1193_36047# a_1592_36047# 0
C17 a_1592_36047# a_1634_36159# 0
C18 a_2017_36047# a_1634_36159# 0
C19 eval tail 0.09536f
C20 a_1193_36047# rx_n 0.28073f
C21 tail vdd_active 1.43419f
C22 vdd_active rx_p 0.14036f
C23 rx_n a_1634_36159# 0.19297f
C24 a_1193_36047# a_1891_36413# 0.12616f
C25 a_1027_36047# capture_clk 0.15126f
C26 a_2017_36047# vdd_capture 0
C27 a_1891_36413# a_1634_36159# 0.03527f
C28 a_1193_36047# a_1381_36047# 0.06685f
C29 captured_q a_1592_36047# 0
C30 a_1193_36047# a_1975_36413# 0
C31 rx_n vdd_capture 1.00475f
C32 a_2017_36047# captured_q 0
C33 a_1381_36047# a_1634_36159# 0
C34 latch_sense_n out_n 0.15098f
C35 tail out_p 0.18071f
C36 a_1975_36413# a_1634_36159# 0.0012f
C37 captured_q rx_n 0
C38 rx_p out_p 0.05225f
C39 eval rx_n 0
C40 rx_n vdd_active 0.25893f
C41 a_1891_36413# vdd_capture 0.87035f
C42 a_1027_36047# a_1193_36047# 0.56916f
C43 a_1027_36047# a_1634_36159# 0.09081f
C44 captured_q a_1891_36413# 0.02036f
C45 latch_sense_p sense_p 0.02861f
C46 a_1381_36047# vdd_capture 0.05355f
C47 a_1975_36413# vdd_capture 0.0041f
C48 a_1381_36047# captured_q 0
C49 out_p reset 0.31048f
C50 vdd_active out_n 3.49958f
C51 a_2017_36047# a_2059_36315# 0
C52 a_1027_36047# vdd_capture 0.48167f
C53 rx_n out_p 0.03556f
C54 a_1193_36047# capture_clk 0.00591f
C55 a_2059_36315# rx_n 0.00177f
C56 a_1027_36047# captured_q 0
C57 rx_n a_1561_36413# 0.01109f
C58 tail rx_n 0.0882f
C59 a_2059_36315# a_1891_36413# 0.2331f
C60 iso_tail sense_p 0.03465f
C61 out_n out_p 2.57005f
C62 a_1381_36047# a_1561_36413# 0.00138f
C63 vdd_capture capture_clk 0.15737f
C64 vdd out_p 0.76206f
C65 tail a_1891_36413# 0
C66 a_1193_36047# a_1634_36159# 0.08345f
C67 sense_n latch_sense_n 0.02861f
C68 captured_q capture_clk 0
C69 tail out_n 0.18071f
C70 a_1592_36047# rx_n 0.01028f
C71 rx_p out_n 0
C72 a_1027_36047# a_2059_36315# 0.02545f
C73 rx_n reset 0.08702f
C74 a_1027_36047# a_1561_36413# 0.00168f
C75 latch_sense_p latch_sense_n 0.05388f
C76 tail vdd 0.94872f
C77 a_2017_36047# rx_n 0
C78 a_1193_36047# vdd_capture 0.25732f
C79 a_1634_36159# vdd_capture 0.14299f
C80 a_1193_36047# captured_q 0
C81 a_2017_36047# a_1891_36413# 0.00937f
C82 captured_q a_1634_36159# 0
C83 a_1891_36413# rx_n 0.54144f
C84 out_n reset 0.31048f
C85 vdd_active latch_sense_n 1.17466f
C86 vdd reset 4.03064f
C87 a_1381_36047# rx_n 0.12252f
C88 rx_n out_n 0.11016f
C89 a_1975_36413# rx_n 0
C90 latch_sense_p vdd_active 0.91317f
C91 rx_n vdd 0.08702f
C92 iso_tail sense_n 0.03465f
C93 captured_q vdd_capture 0.14721f
C94 iso_tail latch_sense_n 0.07366f
C95 a_1975_36413# a_1891_36413# 0.01219f
C96 a_1027_36047# rx_n 0.2778f
C97 iso_tail latch_sense_p 0.07366f
C98 iso_tail vss 21.8637f
C99 sense_n vss 1.81302f
C100 sense_p vss 1.81302f
C101 eq_reset vss 0.42287f
C102 latch_sense_n vss 7.80027f
C103 latch_sense_p vss 8.19727f
C104 rx_p vss 0.78388f
C105 out_n vss 21.4637f
C106 out_p vss 21.5448f
C107 reset vss 5.45976f
C108 tail vss 41.9806f
C109 eval vss 1.02146f
C110 captured_q vss 0.29608f
C111 rx_n vss 11.8457f
C112 capture_clk vss 0.35645f
C113 vdd_active vss 0.12589p
C114 vdd vss 69.78f
C115 vdd_capture vss 6.65069f
C116 a_2017_36047# vss 0.0038f ; **FLOATING
C117 a_1592_36047# vss 0.00445f ; **FLOATING
C118 a_1975_36413# vss 0 ; **FLOATING
C119 a_1381_36047# vss 0.049f ; **FLOATING
C120 a_1891_36413# vss 2.6746f ; **FLOATING
C121 a_2059_36315# vss 0.27959f ; **FLOATING
C122 a_1634_36159# vss 0.18974f ; **FLOATING
C123 a_1193_36047# vss 0.32396f ; **FLOATING
C124 a_1027_36047# vss 0.44166f ; **FLOATING
.ends
