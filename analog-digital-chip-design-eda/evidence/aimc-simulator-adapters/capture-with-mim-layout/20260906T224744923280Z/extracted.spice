* NGSPICE file created from combined_latch_capture.ext - technology: sky130A

.subckt combined_latch_capture out_p out_n latch_sense_p latch_sense_n tail reset
+ vdd vss eval sense_p sense_n iso_tail vdd_active rx_p rx_n eq_reset capture_clk
+ captured_q vdd_capture
X0 vss a_1634_36159# a_1466_36413# vss sky130_fd_pr__nfet_01v8 ad=0.12095 pd=1.085 as=0.0696 ps=0.765 w=0.42 l=0.15
X1 rx_p out_p vss vss sky130_fd_pr__nfet_01v8 ad=0.1218 pd=1.42 as=0.1218 ps=1.42 w=0.42 l=0.15
X2 a_1466_36413# a_1027_36047# a_1466_36413# vdd_capture sky130_fd_pr__pfet_01v8_hvt ad=0.06825 pd=0.745 as=0.2898 ps=3.06 w=0.42 l=0.15
X3 vdd_capture a_1634_36159# a_1466_36413# vdd_capture sky130_fd_pr__pfet_01v8_hvt ad=0.17887 pd=1.26 as=0.07665 ps=0.785 w=0.42 l=0.15
X4 a_1891_36413# a_1027_36047# a_1634_36159# vdd_capture sky130_fd_pr__pfet_01v8_hvt ad=0.0567 pd=0.69 as=0.1095 ps=1.075 w=0.42 l=0.15
X5 out_p out_n vdd_active vdd_active sky130_fd_pr__pfet_01v8 ad=6.72 pd=10.4 as=6.24 ps=10 w=2.4 l=0.6
X6 vss out_n rx_n vss sky130_fd_pr__nfet_01v8 ad=0.1218 pd=1.42 as=0.1218 ps=1.42 w=0.42 l=0.15
X7 vss a_1891_36413# a_2059_36315# vss sky130_fd_pr__nfet_01v8 ad=0.08775 pd=0.92 as=0.169 ps=1.82 w=0.65 l=0.15
X8 latch_sense_n eq_reset latch_sense_p vdd_active sky130_fd_pr__pfet_01v8 ad=3.24 pd=7.8 as=3.24 ps=7.8 w=1.2 l=0.6
X9 a_1891_36413# a_1193_36047# a_1891_36413# vdd_capture sky130_fd_pr__pfet_01v8_hvt ad=0.0567 pd=0.69 as=0.2898 ps=3.06 w=0.42 l=0.15
X10 vdd reset out_n vdd sky130_fd_pr__pfet_01v8 ad=3.12 pd=7.6 as=3.36 ps=8 w=1.2 l=0.6
X11 captured_q a_2059_36315# vss vss sky130_fd_pr__nfet_01v8 ad=0.169 pd=1.82 as=0.08775 ps=0.92 w=0.65 l=0.15
X12 tail out_p out_n vss sky130_fd_pr__nfet_01v8 ad=3.12 pd=7.6 as=3.36 ps=8 w=1.2 l=0.6
X13 a_1466_36413# vss sky130_fd_pr__cap_mim_m3_1 l=2 w=2
X14 a_1634_36159# a_1466_36413# vdd_capture vdd_capture sky130_fd_pr__pfet_01v8_hvt ad=0.1095 pd=1.075 as=0.17887 ps=1.26 w=0.75 l=0.15
X15 a_1891_36413# a_1193_36047# a_1634_36159# vss sky130_fd_pr__special_nfet_01v8 ad=0.0684 pd=0.74 as=0.0989 ps=0.995 w=0.36 l=0.15
X16 out_p reset vdd vdd sky130_fd_pr__pfet_01v8 ad=3.36 pd=8 as=3.12 ps=7.6 w=1.2 l=0.6
X17 a_1466_36413# vdd_capture sky130_fd_pr__cap_mim_m3_1 l=2 w=2
X18 a_1891_36413# a_1027_36047# a_1891_36413# vss sky130_fd_pr__special_nfet_01v8 ad=0.0684 pd=0.74 as=0.2688 ps=2.97 w=0.36 l=0.15
X19 out_p out_n tail vss sky130_fd_pr__nfet_01v8 ad=3.36 pd=8 as=3.12 ps=7.6 w=1.2 l=0.6
X20 a_1381_36047# rx_n vss vss sky130_fd_pr__nfet_01v8 ad=0.0813 pd=0.83 as=0.1092 ps=1.36 w=0.42 l=0.15
X21 tail latch_sense_n out_n vss sky130_fd_pr__nfet_01v8 ad=3.12 pd=7.6 as=3.36 ps=8 w=1.2 l=0.6
X22 vdd_capture a_2059_36315# a_1891_36413# vdd_capture sky130_fd_pr__pfet_01v8_hvt ad=0.1113 pd=1.37 as=0.0882 ps=0.84 w=0.42 l=0.15
X23 tail eval vss vss sky130_fd_pr__nfet_01v8 ad=16.2 pd=17.4 as=16.2 ps=17.4 w=6 l=0.6
X24 a_1891_36413# vss sky130_fd_pr__cap_mim_m3_1 l=2 w=2
X25 a_1466_36413# a_1193_36047# a_1381_36047# vdd_capture sky130_fd_pr__pfet_01v8_hvt ad=0.06825 pd=0.745 as=0.05775 ps=0.695 w=0.42 l=0.15
X26 a_1466_36413# a_1027_36047# a_1381_36047# vss sky130_fd_pr__special_nfet_01v8 ad=0.0621 pd=0.705 as=0.0813 ps=0.83 w=0.36 l=0.15
X27 captured_q a_2059_36315# vdd_capture vdd_capture sky130_fd_pr__pfet_01v8_hvt ad=0.26 pd=2.52 as=0.135 ps=1.27 w=1 l=0.15
X28 vdd_capture a_1891_36413# a_2059_36315# vdd_capture sky130_fd_pr__pfet_01v8_hvt ad=0.135 pd=1.27 as=0.27 ps=2.54 w=1 l=0.15
X29 a_1891_36413# vdd_capture sky130_fd_pr__cap_mim_m3_1 l=2 w=2
X30 out_p latch_sense_p tail vss sky130_fd_pr__nfet_01v8 ad=3.36 pd=8 as=3.12 ps=7.6 w=1.2 l=0.6
X31 a_1381_36047# rx_n vdd_capture vdd_capture sky130_fd_pr__pfet_01v8_hvt ad=0.05775 pd=0.695 as=0.1092 ps=1.36 w=0.42 l=0.15
X32 a_1634_36159# a_1466_36413# vss vss sky130_fd_pr__nfet_01v8 ad=0.0989 pd=0.995 as=0.12095 ps=1.085 w=0.64 l=0.15
X33 vss a_2059_36315# a_1891_36413# vss sky130_fd_pr__nfet_01v8 ad=0.1092 pd=1.36 as=0.066 ps=0.745 w=0.42 l=0.15
X34 iso_tail sense_n latch_sense_n vss sky130_fd_pr__nfet_01v8 ad=3.12 pd=7.6 as=3.36 ps=8 w=1.2 l=0.6
X35 rx_p out_p vdd_active vdd_active sky130_fd_pr__pfet_01v8 ad=0.1218 pd=1.42 as=0.1218 ps=1.42 w=0.42 l=0.15
X36 a_1193_36047# a_1027_36047# vdd_capture vdd_capture sky130_fd_pr__pfet_01v8_hvt ad=0.1664 pd=1.8 as=0.0864 ps=0.91 w=0.64 l=0.15
X37 a_1466_36413# a_1193_36047# a_1466_36413# vss sky130_fd_pr__special_nfet_01v8 ad=0.0621 pd=0.705 as=0.2634 ps=2.94 w=0.36 l=0.15
X38 vdd_active out_n rx_n vdd_active sky130_fd_pr__pfet_01v8 ad=0.1218 pd=1.42 as=0.1218 ps=1.42 w=0.42 l=0.15
X39 vdd_capture capture_clk a_1027_36047# vdd_capture sky130_fd_pr__pfet_01v8_hvt ad=0.0864 pd=0.91 as=0.1664 ps=1.8 w=0.64 l=0.15
X40 a_1193_36047# a_1027_36047# vss vss sky130_fd_pr__nfet_01v8 ad=0.1092 pd=1.36 as=0.0567 ps=0.69 w=0.42 l=0.15
X41 vss capture_clk a_1027_36047# vss sky130_fd_pr__nfet_01v8 ad=0.0567 pd=0.69 as=0.1092 ps=1.36 w=0.42 l=0.15
X42 vdd_active out_p out_n vdd_active sky130_fd_pr__pfet_01v8 ad=6.24 pd=10 as=6.72 ps=10.4 w=2.4 l=0.6
X43 latch_sense_p sense_p iso_tail vss sky130_fd_pr__nfet_01v8 ad=3.36 pd=8 as=3.12 ps=7.6 w=1.2 l=0.6
C0 vdd out_p 0.76206f
C1 rx_n tail 0.08754f
C2 a_1466_36413# a_1027_36047# 0.20748f
C3 a_2059_36315# captured_q 0.06507f
C4 vdd_active out_n 3.49958f
C5 a_1193_36047# a_1381_36047# 0.06685f
C6 out_n tail 0.18071f
C7 a_1891_36413# captured_q 0.02052f
C8 a_1466_36413# capture_clk 0.00206f
C9 a_1466_36413# rx_n 0.14698f
C10 a_1634_36159# captured_q 0
C11 vdd_active tail 1.43419f
C12 a_1193_36047# a_1027_36047# 0.56916f
C13 a_1634_36159# a_1381_36047# 0
C14 a_1466_36413# vdd_capture 0.88609f
C15 rx_n out_p 0.03556f
C16 a_1193_36047# capture_clk 0.00591f
C17 a_1466_36413# tail 0
C18 out_n out_p 2.57005f
C19 a_1193_36047# rx_n 0.17923f
C20 latch_sense_p sense_p 0.02861f
C21 a_2059_36315# a_1027_36047# 0.02545f
C22 a_1027_36047# a_1891_36413# 0.04078f
C23 vdd reset 4.03064f
C24 a_2059_36315# rx_n 0.00177f
C25 a_1634_36159# a_1027_36047# 0.09081f
C26 latch_sense_p latch_sense_n 0.05388f
C27 rx_n a_1891_36413# 0.01929f
C28 vdd_active out_p 3.44635f
C29 latch_sense_p iso_tail 0.07366f
C30 a_1381_36047# captured_q 0
C31 tail out_p 0.18071f
C32 a_1193_36047# vdd_capture 0.25732f
C33 a_1634_36159# rx_n 0.00813f
C34 rx_n eval 0
C35 a_2059_36315# vdd_capture 0.32086f
C36 a_1466_36413# a_1193_36047# 0.11103f
C37 latch_sense_p eq_reset 0.02611f
C38 vdd_capture a_1891_36413# 0.87453f
C39 rx_n reset 0.08702f
C40 rx_p out_n 0
C41 iso_tail sense_p 0.03465f
C42 a_1027_36047# captured_q 0
C43 a_1891_36413# tail 0
C44 a_1634_36159# vdd_capture 0.14299f
C45 out_n reset 0.31048f
C46 capture_clk captured_q 0
C47 rx_n captured_q 0
C48 a_1466_36413# a_1891_36413# 0.59651f
C49 latch_sense_n iso_tail 0.07366f
C50 a_1027_36047# a_1381_36047# 0.04548f
C51 tail eval 0.09536f
C52 rx_p vdd_active 0.14036f
C53 a_1466_36413# a_1634_36159# 0.20027f
C54 latch_sense_p vdd_active 0.91317f
C55 latch_sense_p tail 0.0334f
C56 rx_n a_1381_36047# 0.09104f
C57 rx_n vdd 0.08702f
C58 out_n vdd 0.76206f
C59 vdd_capture captured_q 0.14721f
C60 latch_sense_n eq_reset 0.02611f
C61 a_2059_36315# a_1193_36047# 0.01914f
C62 a_1193_36047# a_1891_36413# 0.12664f
C63 latch_sense_n out_n 0.15098f
C64 a_1466_36413# captured_q 0
C65 a_1027_36047# capture_clk 0.15126f
C66 vdd_capture a_1381_36047# 0.05355f
C67 a_1634_36159# a_1193_36047# 0.08311f
C68 a_1027_36047# rx_n 0.0711f
C69 a_2059_36315# a_1891_36413# 0.23318f
C70 vdd tail 0.94872f
C71 rx_p out_p 0.05225f
C72 latch_sense_p out_p 0.15098f
C73 rx_n capture_clk 0.01314f
C74 reset out_p 0.31048f
C75 vdd_active latch_sense_n 1.17466f
C76 latch_sense_n sense_n 0.02861f
C77 a_2059_36315# a_1634_36159# 0
C78 iso_tail sense_n 0.03465f
C79 a_1466_36413# a_1381_36047# 0.03238f
C80 latch_sense_n tail 0.0334f
C81 rx_n out_n 0.11016f
C82 a_1634_36159# a_1891_36413# 0.03584f
C83 vdd_capture a_1027_36047# 0.48167f
C84 a_1193_36047# captured_q 0
C85 vdd_capture capture_clk 0.15737f
C86 vdd_capture rx_n 0.12954f
C87 vdd_active eq_reset 1.50445f
C88 rx_n vdd_active 0.25893f
C89 iso_tail vss 21.8637f
C90 sense_n vss 1.81302f
C91 sense_p vss 1.81302f
C92 eq_reset vss 0.42287f
C93 latch_sense_n vss 7.80027f
C94 latch_sense_p vss 8.19727f
C95 rx_p vss 0.78388f
C96 out_n vss 21.4637f
C97 out_p vss 21.5448f
C98 reset vss 5.45976f
C99 tail vss 41.9806f
C100 eval vss 1.02146f
C101 captured_q vss 0.29608f
C102 rx_n vss 8.86877f
C103 capture_clk vss 0.35645f
C104 vdd_active vss 0.12589p
C105 vdd vss 69.78f
C106 vdd_capture vss 6.65067f
C107 a_1381_36047# vss 0.049f ; **FLOATING
C108 a_1891_36413# vss 2.6478f ; **FLOATING
C109 a_2059_36315# vss 0.27959f ; **FLOATING
C110 a_1466_36413# vss 3.10414f ; **FLOATING
C111 a_1634_36159# vss 0.18446f ; **FLOATING
C112 a_1193_36047# vss 0.31613f ; **FLOATING
C113 a_1027_36047# vss 0.44166f ; **FLOATING
.ends
