* NGSPICE file created from combined_latch_capture.ext - technology: sky130A

.subckt combined_latch_capture out_p out_n latch_sense_p latch_sense_n tail reset
+ vdd vss eval sense_p sense_n iso_tail vdd_active rx_p rx_n eq_reset capture_clk
+ captured_q vdd_capture
X0 vss a_1634_36159# a_1592_36047# vss sky130_fd_pr__nfet_01v8 ad=0.12095 pd=1.085 as=0.2697 ps=2.145 w=0.42 l=0.15
X1 rx_p out_p vss vss sky130_fd_pr__nfet_01v8 ad=0.1218 pd=1.42 as=0.1218 ps=1.42 w=0.42 l=0.15
X2 a_1561_36413# a_1027_36047# a_1466_36413# vdd_capture sky130_fd_pr__pfet_01v8_hvt ad=0.24485 pd=1.945 as=0.06825 ps=0.745 w=0.42 l=0.15
X3 vdd_capture a_1634_36159# a_1561_36413# vdd_capture sky130_fd_pr__pfet_01v8_hvt ad=0.17887 pd=1.26 as=0.24485 ps=1.945 w=0.42 l=0.15
X4 a_1891_36413# a_1027_36047# a_1634_36159# vdd_capture sky130_fd_pr__pfet_01v8_hvt ad=0.0567 pd=0.69 as=0.1095 ps=1.075 w=0.42 l=0.15
X5 out_p out_n vdd_active vdd_active sky130_fd_pr__pfet_01v8 ad=6.72 pd=10.4 as=6.24 ps=10 w=2.4 l=0.6
X6 vss out_n rx_n vss sky130_fd_pr__nfet_01v8 ad=0.1218 pd=1.42 as=0.1218 ps=1.42 w=0.42 l=0.15
X7 vss a_1891_36413# a_2059_36315# vss sky130_fd_pr__nfet_01v8 ad=0.08775 pd=0.92 as=0.169 ps=1.82 w=0.65 l=0.15
X8 latch_sense_n eq_reset latch_sense_p vdd_active sky130_fd_pr__pfet_01v8 ad=3.24 pd=7.8 as=3.24 ps=7.8 w=1.2 l=0.6
X9 a_1975_36413# a_1193_36047# a_1891_36413# vdd_capture sky130_fd_pr__pfet_01v8_hvt ad=0.2564 pd=2 as=0.0567 ps=0.69 w=0.42 l=0.15
X10 vdd reset out_n vdd sky130_fd_pr__pfet_01v8 ad=3.12 pd=7.6 as=3.36 ps=8 w=1.2 l=0.6
X11 captured_q a_2059_36315# vss vss sky130_fd_pr__nfet_01v8 ad=0.169 pd=1.82 as=0.08775 ps=0.92 w=0.65 l=0.15
X12 tail out_p out_n vss sky130_fd_pr__nfet_01v8 ad=3.12 pd=7.6 as=3.36 ps=8 w=1.2 l=0.6
X13 a_1592_36047# vss sky130_fd_pr__cap_mim_m3_1 l=2 w=2
X14 a_1634_36159# a_1466_36413# vdd_capture vdd_capture sky130_fd_pr__pfet_01v8_hvt ad=0.1095 pd=1.075 as=0.17887 ps=1.26 w=0.75 l=0.15
X15 a_1891_36413# a_1193_36047# a_1634_36159# vss sky130_fd_pr__special_nfet_01v8 ad=0.0684 pd=0.74 as=0.0989 ps=0.995 w=0.36 l=0.15
X16 out_p reset vdd vdd sky130_fd_pr__pfet_01v8 ad=3.36 pd=8 as=3.12 ps=7.6 w=1.2 l=0.6
X17 a_1561_36413# vdd_capture sky130_fd_pr__cap_mim_m3_1 l=2 w=2
X18 a_2017_36047# a_1027_36047# a_1891_36413# vss sky130_fd_pr__special_nfet_01v8 ad=0.2661 pd=2.125 as=0.0684 ps=0.74 w=0.36 l=0.15
X19 out_p out_n tail vss sky130_fd_pr__nfet_01v8 ad=3.36 pd=8 as=3.12 ps=7.6 w=1.2 l=0.6
X20 a_1381_36047# rx_n vss vss sky130_fd_pr__nfet_01v8 ad=0.0813 pd=0.83 as=0.1092 ps=1.36 w=0.42 l=0.15
X21 tail latch_sense_n out_n vss sky130_fd_pr__nfet_01v8 ad=3.12 pd=7.6 as=3.36 ps=8 w=1.2 l=0.6
X22 vdd_capture a_2059_36315# a_1975_36413# vdd_capture sky130_fd_pr__pfet_01v8_hvt ad=0.1113 pd=1.37 as=0.2564 ps=2 w=0.42 l=0.15
X23 tail eval vss vss sky130_fd_pr__nfet_01v8 ad=16.2 pd=17.4 as=16.2 ps=17.4 w=6 l=0.6
X24 a_2017_36047# vss sky130_fd_pr__cap_mim_m3_1 l=2 w=2
X25 a_1466_36413# a_1193_36047# a_1381_36047# vdd_capture sky130_fd_pr__pfet_01v8_hvt ad=0.06825 pd=0.745 as=0.05775 ps=0.695 w=0.42 l=0.15
X26 a_1466_36413# a_1027_36047# a_1381_36047# vss sky130_fd_pr__special_nfet_01v8 ad=0.0621 pd=0.705 as=0.0813 ps=0.83 w=0.36 l=0.15
X27 captured_q a_2059_36315# vdd_capture vdd_capture sky130_fd_pr__pfet_01v8_hvt ad=0.26 pd=2.52 as=0.135 ps=1.27 w=1 l=0.15
X28 vdd_capture a_1891_36413# a_2059_36315# vdd_capture sky130_fd_pr__pfet_01v8_hvt ad=0.135 pd=1.27 as=0.27 ps=2.54 w=1 l=0.15
X29 a_1975_36413# vdd_capture sky130_fd_pr__cap_mim_m3_1 l=2 w=2
X30 out_p latch_sense_p tail vss sky130_fd_pr__nfet_01v8 ad=3.36 pd=8 as=3.12 ps=7.6 w=1.2 l=0.6
X31 a_1381_36047# rx_n vdd_capture vdd_capture sky130_fd_pr__pfet_01v8_hvt ad=0.05775 pd=0.695 as=0.1092 ps=1.36 w=0.42 l=0.15
X32 a_1634_36159# a_1466_36413# vss vss sky130_fd_pr__nfet_01v8 ad=0.0989 pd=0.995 as=0.12095 ps=1.085 w=0.64 l=0.15
X33 vss a_2059_36315# a_2017_36047# vss sky130_fd_pr__nfet_01v8 ad=0.1092 pd=1.36 as=0.2661 ps=2.125 w=0.42 l=0.15
X34 iso_tail sense_n latch_sense_n vss sky130_fd_pr__nfet_01v8 ad=3.12 pd=7.6 as=3.36 ps=8 w=1.2 l=0.6
X35 rx_p out_p vdd_active vdd_active sky130_fd_pr__pfet_01v8 ad=0.1218 pd=1.42 as=0.1218 ps=1.42 w=0.42 l=0.15
X36 a_1193_36047# a_1027_36047# vdd_capture vdd_capture sky130_fd_pr__pfet_01v8_hvt ad=0.1664 pd=1.8 as=0.0864 ps=0.91 w=0.64 l=0.15
X37 a_1592_36047# a_1193_36047# a_1466_36413# vss sky130_fd_pr__special_nfet_01v8 ad=0.2697 pd=2.145 as=0.0621 ps=0.705 w=0.36 l=0.15
X38 vdd_active out_n rx_n vdd_active sky130_fd_pr__pfet_01v8 ad=0.1218 pd=1.42 as=0.1218 ps=1.42 w=0.42 l=0.15
X39 vdd_capture capture_clk a_1027_36047# vdd_capture sky130_fd_pr__pfet_01v8_hvt ad=0.0864 pd=0.91 as=0.1664 ps=1.8 w=0.64 l=0.15
X40 a_1193_36047# a_1027_36047# vss vss sky130_fd_pr__nfet_01v8 ad=0.1092 pd=1.36 as=0.0567 ps=0.69 w=0.42 l=0.15
X41 vss capture_clk a_1027_36047# vss sky130_fd_pr__nfet_01v8 ad=0.0567 pd=0.69 as=0.1092 ps=1.36 w=0.42 l=0.15
X42 vdd_active out_p out_n vdd_active sky130_fd_pr__pfet_01v8 ad=6.24 pd=10 as=6.72 ps=10.4 w=2.4 l=0.6
X43 latch_sense_p sense_p iso_tail vss sky130_fd_pr__nfet_01v8 ad=3.36 pd=8 as=3.12 ps=7.6 w=1.2 l=0.6
C0 a_1634_36159# a_1193_36047# 0.08347f
C1 a_1634_36159# a_1466_36413# 0.16113f
C2 a_2059_36315# a_1193_36047# 0.01914f
C3 a_1561_36413# a_1027_36047# 0.00739f
C4 latch_sense_n tail 0.0334f
C5 latch_sense_p latch_sense_n 0.05388f
C6 rx_n vdd 0.08702f
C7 a_1634_36159# captured_q 0.00147f
C8 a_2059_36315# captured_q 0.0652f
C9 out_p reset 0.31048f
C10 out_n rx_p 0
C11 sense_n latch_sense_n 0.02861f
C12 sense_p iso_tail 0.03465f
C13 a_1891_36413# a_1975_36413# 0.01849f
C14 a_1027_36047# a_2017_36047# 0.00127f
C15 a_1561_36413# rx_n 0.01049f
C16 a_1561_36413# vdd_capture 0.68515f
C17 capture_clk a_1027_36047# 0.15126f
C18 a_1634_36159# a_1891_36413# 0.0205f
C19 rx_n a_1027_36047# 0.07135f
C20 vdd tail 0.94872f
C21 a_1891_36413# a_2059_36315# 0.20625f
C22 a_1634_36159# a_1381_36047# 0
C23 a_1027_36047# vdd_capture 0.50462f
C24 iso_tail latch_sense_p 0.07366f
C25 rx_n out_n 0.11016f
C26 a_1561_36413# a_1592_36047# 0.00154f
C27 a_1027_36047# a_1592_36047# 0
C28 iso_tail sense_n 0.03465f
C29 vdd_active latch_sense_n 1.17466f
C30 rx_n a_2017_36047# 0.0167f
C31 vdd out_p 0.76206f
C32 a_1634_36159# a_1975_36413# 0.00131f
C33 a_2017_36047# vdd_capture 0.00588f
C34 a_2059_36315# a_1975_36413# 0
C35 rx_n capture_clk 0.01314f
C36 capture_clk vdd_capture 0.15737f
C37 a_1561_36413# a_1193_36047# 0.0022f
C38 latch_sense_p eq_reset 0.02611f
C39 a_1561_36413# a_1466_36413# 0.01257f
C40 a_1634_36159# a_2059_36315# 0
C41 rx_n vdd_capture 0.13269f
C42 a_2017_36047# a_1592_36047# 0.3196f
C43 a_1193_36047# a_1027_36047# 0.56916f
C44 a_1466_36413# a_1027_36047# 0.16041f
C45 out_n tail 0.18071f
C46 rx_n a_1592_36047# 0.11005f
C47 a_1592_36047# vdd_capture 0.01036f
C48 captured_q a_1027_36047# 0
C49 a_2017_36047# tail 0
C50 rx_p out_p 0.05225f
C51 a_1193_36047# a_2017_36047# 0
C52 out_n out_p 2.57005f
C53 rx_n tail 0.08754f
C54 capture_clk a_1193_36047# 0.00591f
C55 rx_n a_1193_36047# 0.17985f
C56 rx_n a_1466_36413# 0.0176f
C57 captured_q a_2017_36047# 0
C58 a_1193_36047# vdd_capture 0.26579f
C59 a_1466_36413# vdd_capture 0.20112f
C60 a_1561_36413# a_1381_36047# 0.00138f
C61 capture_clk captured_q 0
C62 a_1592_36047# tail 0
C63 a_1891_36413# a_1027_36047# 0.03079f
C64 rx_n captured_q 0.0027f
C65 a_1381_36047# a_1027_36047# 0.04548f
C66 vdd reset 4.03064f
C67 rx_n out_p 0.03556f
C68 vdd_active eq_reset 1.50445f
C69 a_1193_36047# a_1592_36047# 0.00234f
C70 captured_q vdd_capture 0.14721f
C71 a_1466_36413# a_1592_36047# 0.00931f
C72 sense_p latch_sense_p 0.02861f
C73 vdd_active rx_p 0.14036f
C74 iso_tail latch_sense_n 0.07366f
C75 a_1561_36413# a_1975_36413# 0.20641f
C76 vdd_active out_n 3.49958f
C77 captured_q a_1592_36047# 0
C78 latch_sense_p tail 0.0334f
C79 a_1891_36413# a_2017_36047# 0.01536f
C80 a_1975_36413# a_1027_36047# 0.00207f
C81 a_1561_36413# a_1634_36159# 0.00105f
C82 a_1193_36047# a_1466_36413# 0.07623f
C83 rx_n a_1891_36413# 0.00434f
C84 rx_n eval 0
C85 a_1634_36159# a_1027_36047# 0.09081f
C86 rx_n a_1381_36047# 0.09104f
C87 a_1891_36413# vdd_capture 0.15611f
C88 a_2059_36315# a_1027_36047# 0.02545f
C89 a_1381_36047# vdd_capture 0.0536f
C90 out_p tail 0.18071f
C91 rx_n vdd_active 0.25893f
C92 eq_reset latch_sense_n 0.02611f
C93 captured_q a_1193_36047# 0
C94 latch_sense_p out_p 0.15098f
C95 captured_q a_1466_36413# 0
C96 out_n reset 0.31048f
C97 a_1975_36413# a_2017_36047# 0.00991f
C98 out_n latch_sense_n 0.15098f
C99 a_1634_36159# a_2017_36047# 0
C100 a_2059_36315# a_2017_36047# 0.00393f
C101 a_1975_36413# vdd_capture 0.70365f
C102 a_1634_36159# rx_n 0.01015f
C103 tail eval 0.09536f
C104 rx_n a_2059_36315# 0.0026f
C105 rx_n reset 0.08702f
C106 a_1634_36159# vdd_capture 0.14813f
C107 a_1891_36413# a_1193_36047# 0.1112f
C108 a_2059_36315# vdd_capture 0.32648f
C109 a_1381_36047# a_1193_36047# 0.06685f
C110 a_1381_36047# a_1466_36413# 0.02068f
C111 vdd_active tail 1.43419f
C112 vdd_active latch_sense_p 0.91317f
C113 a_1634_36159# a_1592_36047# 0.00421f
C114 a_1891_36413# captured_q 0.00598f
C115 a_1381_36047# captured_q 0
C116 out_n vdd 0.76206f
C117 a_1193_36047# a_1975_36413# 0.00461f
C118 vdd_active out_p 3.44635f
C119 iso_tail vss 21.8637f
C120 sense_n vss 1.81302f
C121 sense_p vss 1.81302f
C122 eq_reset vss 0.42287f
C123 latch_sense_n vss 7.80027f
C124 latch_sense_p vss 8.19727f
C125 rx_p vss 0.78388f
C126 out_n vss 21.4637f
C127 out_p vss 21.5448f
C128 reset vss 5.45976f
C129 tail vss 41.9806f
C130 eval vss 1.02146f
C131 captured_q vss 0.29833f
C132 rx_n vss 8.85611f
C133 capture_clk vss 0.35645f
C134 vdd_active vss 0.12589p
C135 vdd vss 69.78f
C136 vdd_capture vss 6.98975f
C137 a_2017_36047# vss 1.61217f ; **FLOATING
C138 a_1592_36047# vss 1.89352f ; **FLOATING
C139 a_1381_36047# vss 0.04915f ; **FLOATING
C140 a_1891_36413# vss 0.21436f ; **FLOATING
C141 a_2059_36315# vss 0.27527f ; **FLOATING
C142 a_1466_36413# vss 0.15336f ; **FLOATING
C143 a_1634_36159# vss 0.18699f ; **FLOATING
C144 a_1975_36413# vss 0.78749f ; **FLOATING
C145 a_1193_36047# vss 0.32353f ; **FLOATING
C146 a_1027_36047# vss 0.43125f ; **FLOATING
C147 a_1561_36413# vss 0.98765f ; **FLOATING
.ends
