* Signed small-signal extracted latch diagnostic, no structural MOS substitution.
.option scale=1u
.param mc_mm_switch=0 mc_pr_switch=0
.include "/home/mehtama1/eda-tools/pdks/sky130A/libs.ref/sky130_fd_pr/spice/sky130_fd_pr__nfet_01v8__tt.pm3.spice"
.include "/home/mehtama1/eda-tools/pdks/sky130A/libs.ref/sky130_fd_pr/spice/sky130_fd_pr__nfet_01v8__mismatch.corner.spice"
.include "/home/mehtama1/eda-tools/pdks/sky130A/libs.ref/sky130_fd_pr/spice/sky130_fd_pr__pfet_01v8__tt.corner.spice"
.include "/home/mehtama1/eda-tools/pdks/sky130A/libs.ref/sky130_fd_pr/spice/sky130_fd_pr__pfet_01v8__mismatch.corner.spice"
* SKY130 Spice File.
.option scale=1.0u
.include "/home/mehtama1/eda-tools/pdks/sky130A/libs.tech/ngspice/parameters/lod.spice"
.param
+ lv_dlc_rotweak = .00e-9
+ lvhvt_dlc_rotweak = .00e-9
+ lvt_dlc_rotweak = .00e-9
+ hv_dlc_rotweak = .00e-9
+ sky130_fd_pr__nfet_01v8__dlc_rotweak = lv_dlc_rotweak
+ sky130_fd_pr__esd_nfet_01v8__dlc_rotweak = lv_dlc_rotweak
+ sky130_fd_pr__nfet_01v8_lvt__dlc_rotweak = lvt_dlc_rotweak
+ sky130_fd_pr__pfet_01v8__dlc_rotweak = lv_dlc_rotweak
+ sky130_fd_pr__pfet_01v8_lvt__dlc_rotweak = lvt_dlc_rotweak
+ sky130_fd_pr__pfet_01v8_hvt__dlc_rotweak = lvhvt_dlc_rotweak
+ sky130_fd_pr__esd_nfet_g5v0d10v5__dlc_rotweak = hv_dlc_rotweak
+ sky130_fd_pr__esd_pfet_g5v0d10v5__dlc_rotweak = hv_dlc_rotweak
+ sky130_fd_pr__nfet_03v3_nvt__dlc_rotweak = hv_dlc_rotweak
+ sky130_fd_pr__nfet_05v0_nvt__dlc_rotweak = hv_dlc_rotweak
+ sky130_fd_pr__nfet_g5v0d10v5__dlc_rotweak = hv_dlc_rotweak
+ sky130_fd_pr__pfet_g5v0d10v5__dlc_rotweak = hv_dlc_rotweak
+ sky130_fd_pr__pfet_g5v0d16v0__dlc_rotweak = hv_dlc_rotweak
+ sky130_fd_pr__special_nfet_pass__dlc_rotweak = lv_dlc_rotweak
+ sky130_fd_pr__special_nfet_pass_lowleakage__dlc_rotweak = lv_dlc_rotweak
+ sky130_fd_pr__special_nfet_pass_flash__dlc_rotweak = hv_dlc_rotweak
+ sky130_fd_pr__special_nfet_latch__dlc_rotweak = lv_dlc_rotweak
+ sky130_fd_pr__special_nfet_latch_lowleakage__dlc_rotweak = lv_dlc_rotweak
+ sky130_fd_pr__special_pfet_latch__dlc_rotweak = lv_dlc_rotweak
+ sky130_fd_pr__special_pfet_latch_lowleakage__dlc_rotweak = lv_dlc_rotweak
+ sky130_fd_bs_flash__special_sonosfet_star__dlc_rotweak = hv_dlc_rotweak
+ sky130_fd_bs_flash__special_sonosfet_original__dlc_rotweak = hv_dlc_rotweak
+ sonos_eeol_dlc_rotweak = hv_dlc_rotweak
+ sonos_peol_dlc_rotweak = hv_dlc_rotweak

.include "/home/mehtama1/git-repo/ai-hardware-analysis/analog-digital-chip-design-eda/evidence/aimc-simulator-adapters/latch-capture-integration/20260906T224013473263Z/circuit.spice"
.temp 25
.options method=gear reltol=1e-05 abstol=1e-14 vntol=1e-7
VDD vdd 0 1.75
VACTIVE vdd_active 0 1.8
VSS vss 0 0
VP sense_p 0 PWL(0n 0.89975 45n 0.89975 45.02n 0.90025 95n 0.90025 95.02n 0.89975 145n 0.89975 145.02n 0.90025)
VN sense_n 0 PWL(0n 0.90025 45n 0.90025 45.02n 0.89975 95n 0.89975 95.02n 0.90025 145n 0.90025 145.02n 0.89975)
IBIAS iso_tail 0 4u
RP vdd_active latch_sense_p 350000
RN vdd_active latch_sense_n 350000
VRESET reset 0 PULSE(0 1.75 8n 20p 1000p 29.5n 50n)
VEVAL eval 0 PULSE(0 1.8 7.8n 20p 1000p 30n 50n)
VEQRESET eq_reset 0 PULSE(0 1.8 2n 20p 1000p 35.5n 50n)
XU out_p out_n latch_sense_p latch_sense_n tail reset vdd vss eval sense_p sense_n iso_tail vdd_active rx_p rx_n eq_reset capture_clk captured_q vdd_capture combined_latch_capture

CRXp rx_p vss 2f
CRXn rx_n vss 2f
.include "/home/mehtama1/eda-tools/pdks/sky130A/libs.ref/sky130_fd_pr/spice/sky130_fd_pr__pfet_01v8_hvt__tt.pm3.spice"
.include "/home/mehtama1/eda-tools/pdks/sky130A/libs.ref/sky130_fd_pr/spice/sky130_fd_pr__pfet_01v8_hvt__mismatch.corner.spice"
.include "/home/mehtama1/eda-tools/pdks/ciel/sky130/versions/0fe599b2afb6708d281543108caf8310912f54af/sky130A/libs.tech/ngspice/r+c/res_typical__cap_typical.spice"
.include "/home/mehtama1/eda-tools/pdks/ciel/sky130/versions/0fe599b2afb6708d281543108caf8310912f54af/sky130A/libs.tech/ngspice/r+c/res_typical__cap_typical__lin.spice"
.include "/home/mehtama1/eda-tools/pdks/ciel/sky130/versions/0fe599b2afb6708d281543108caf8310912f54af/sky130A/libs.ref/sky130_fd_pr/spice/sky130_fd_pr__cap_mim_m3_1.model.spice"
VDCAP vdd_capture 0 1.8
VCAP capture_clk 0 PULSE(0 1.8 20n 100p 100p 5n 50n)
* Capture transistors are part of the combined extraction
CCAP captured_q vss 2f
.tran 20p 200n 0 5p
.measure tran op_final FIND v(out_p) AT=18n
.measure tran on_final FIND v(out_n) AT=18n
.measure tran lp_before FIND v(latch_sense_p) AT=7.6n
.measure tran ln_before FIND v(latch_sense_n) AT=7.6n
.control
run
write waveform.raw v(out_p) v(out_n) v(latch_sense_p) v(latch_sense_n) v(iso_tail) v(tail) v(reset) v(eval) v(eq_reset) v(rx_p) v(rx_n) v(capture_clk) v(captured_q) v(sense_p) v(sense_n) i(vdd) i(vactive) i(vdcap) i(vcap) i(vreset) i(veval) i(veqreset) i(vp) i(vn) v(xu.a_1027_36047#) v(xu.a_1193_36047#) v(xu.a_1381_36047#) v(xu.a_1466_36413#) v(xu.a_1561_36413#) v(xu.a_1592_36047#) v(xu.a_1634_36159#) v(xu.a_1891_36413#) v(xu.a_1975_36413#) v(xu.a_2017_36047#) v(xu.a_2059_36315#) v(xu.xcharge0.a) v(xu.xcharge0.b1) v(xu.xcharge1.a) v(xu.xcharge1.b1) v(xu.xcharge2.a) v(xu.xcharge2.b1) v(xu.xcharge3.a) v(xu.xcharge3.b1)
.endc
.end
