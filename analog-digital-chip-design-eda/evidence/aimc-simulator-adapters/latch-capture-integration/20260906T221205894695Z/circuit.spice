* NGSPICE file created from combined_latch_capture.ext - technology: sky130A

.subckt combined_latch_capture out_p out_n latch_sense_p latch_sense_n tail reset
+ vdd vss eval sense_p sense_n iso_tail vdd_active rx_p rx_n eq_reset capture_clk
+ captured_q vdd_capture
X0 vss a_1634_36159# a_1592_36047# vss sky130_fd_pr__nfet_01v8 ad=0.12095 pd=1.085 as=0.0696 ps=0.765 w=0.42 l=0.15
X1 rx_p out_p vss vss sky130_fd_pr__nfet_01v8 ad=0.1218 pd=1.42 as=0.1218 ps=1.42 w=0.42 l=0.15
X2 a_1561_36413# a_1027_36047# a_1466_36413# vdd_capture sky130_fd_pr__pfet_01v8_hvt ad=0.07665 pd=0.785 as=0.06825 ps=0.745 w=0.42 l=0.15
X3 vdd_capture a_1634_36159# a_1561_36413# vdd_capture sky130_fd_pr__pfet_01v8_hvt ad=0.17887 pd=1.26 as=0.07665 ps=0.785 w=0.42 l=0.15
X4 a_1891_36413# a_1027_36047# a_1634_36159# vdd_capture sky130_fd_pr__pfet_01v8_hvt ad=0.0567 pd=0.69 as=0.1095 ps=1.075 w=0.42 l=0.15
X5 out_p out_n vdd_active vdd_active sky130_fd_pr__pfet_01v8 ad=6.72 pd=10.4 as=6.24 ps=10 w=2.4 l=0.6
X6 vss out_n rx_n vss sky130_fd_pr__nfet_01v8 ad=0.1218 pd=1.42 as=0.1218 ps=1.42 w=0.42 l=0.15
X7 vss a_1891_36413# a_2059_36315# vss sky130_fd_pr__nfet_01v8 ad=0.08775 pd=0.92 as=0.169 ps=1.82 w=0.65 l=0.15
X8 latch_sense_n eq_reset latch_sense_p vdd_active sky130_fd_pr__pfet_01v8 ad=3.24 pd=7.8 as=3.24 ps=7.8 w=1.2 l=0.6
X9 a_1975_36413# a_1193_36047# a_1891_36413# vdd_capture sky130_fd_pr__pfet_01v8_hvt ad=0.0882 pd=0.84 as=0.0567 ps=0.69 w=0.42 l=0.15
X10 vdd reset out_n vdd sky130_fd_pr__pfet_01v8 ad=3.12 pd=7.6 as=3.36 ps=8 w=1.2 l=0.6
X11 captured_q a_2059_36315# vss vss sky130_fd_pr__nfet_01v8 ad=0.169 pd=1.82 as=0.08775 ps=0.92 w=0.65 l=0.15
X12 tail out_p out_n vss sky130_fd_pr__nfet_01v8 ad=3.12 pd=7.6 as=3.36 ps=8 w=1.2 l=0.6
X13 a_1634_36159# a_1466_36413# vdd_capture vdd_capture sky130_fd_pr__pfet_01v8_hvt ad=0.1095 pd=1.075 as=0.17887 ps=1.26 w=0.75 l=0.15
X14 a_1891_36413# a_1193_36047# a_1634_36159# vss sky130_fd_pr__special_nfet_01v8 ad=0.0684 pd=0.74 as=0.0989 ps=0.995 w=0.36 l=0.15
X15 out_p reset vdd vdd sky130_fd_pr__pfet_01v8 ad=3.36 pd=8 as=3.12 ps=7.6 w=1.2 l=0.6
X16 a_2017_36047# a_1027_36047# a_1891_36413# vss sky130_fd_pr__special_nfet_01v8 ad=0.066 pd=0.745 as=0.0684 ps=0.74 w=0.36 l=0.15
X17 out_p out_n tail vss sky130_fd_pr__nfet_01v8 ad=3.36 pd=8 as=3.12 ps=7.6 w=1.2 l=0.6
X18 a_1381_36047# rx_n vss vss sky130_fd_pr__nfet_01v8 ad=0.0813 pd=0.83 as=0.1092 ps=1.36 w=0.42 l=0.15
X19 tail latch_sense_n out_n vss sky130_fd_pr__nfet_01v8 ad=3.12 pd=7.6 as=3.36 ps=8 w=1.2 l=0.6
X20 vdd_capture a_2059_36315# a_1975_36413# vdd_capture sky130_fd_pr__pfet_01v8_hvt ad=0.1113 pd=1.37 as=0.0882 ps=0.84 w=0.42 l=0.15
X21 tail eval vss vss sky130_fd_pr__nfet_01v8 ad=16.2 pd=17.4 as=16.2 ps=17.4 w=6 l=0.6
X22 a_1466_36413# a_1193_36047# a_1381_36047# vdd_capture sky130_fd_pr__pfet_01v8_hvt ad=0.06825 pd=0.745 as=0.05775 ps=0.695 w=0.42 l=0.15
X23 a_1466_36413# a_1027_36047# a_1381_36047# vss sky130_fd_pr__special_nfet_01v8 ad=0.0621 pd=0.705 as=0.0813 ps=0.83 w=0.36 l=0.15
X24 captured_q a_2059_36315# vdd_capture vdd_capture sky130_fd_pr__pfet_01v8_hvt ad=0.26 pd=2.52 as=0.135 ps=1.27 w=1 l=0.15
X25 vdd_capture a_1891_36413# a_2059_36315# vdd_capture sky130_fd_pr__pfet_01v8_hvt ad=0.135 pd=1.27 as=0.27 ps=2.54 w=1 l=0.15
X26 out_p latch_sense_p tail vss sky130_fd_pr__nfet_01v8 ad=3.36 pd=8 as=3.12 ps=7.6 w=1.2 l=0.6
X27 a_1381_36047# rx_n vdd_capture vdd_capture sky130_fd_pr__pfet_01v8_hvt ad=0.05775 pd=0.695 as=0.1092 ps=1.36 w=0.42 l=0.15
X28 a_1634_36159# a_1466_36413# vss vss sky130_fd_pr__nfet_01v8 ad=0.0989 pd=0.995 as=0.12095 ps=1.085 w=0.64 l=0.15
X29 vss a_2059_36315# a_2017_36047# vss sky130_fd_pr__nfet_01v8 ad=0.1092 pd=1.36 as=0.066 ps=0.745 w=0.42 l=0.15
X30 iso_tail sense_n latch_sense_n vss sky130_fd_pr__nfet_01v8 ad=3.12 pd=7.6 as=3.36 ps=8 w=1.2 l=0.6
X31 rx_p out_p vdd_active vdd_active sky130_fd_pr__pfet_01v8 ad=0.1218 pd=1.42 as=0.1218 ps=1.42 w=0.42 l=0.15
X32 a_1193_36047# a_1027_36047# vdd_capture vdd_capture sky130_fd_pr__pfet_01v8_hvt ad=0.1664 pd=1.8 as=0.0864 ps=0.91 w=0.64 l=0.15
X33 a_1592_36047# a_1193_36047# a_1466_36413# vss sky130_fd_pr__special_nfet_01v8 ad=0.0696 pd=0.765 as=0.0621 ps=0.705 w=0.36 l=0.15
X34 vdd_active out_n rx_n vdd_active sky130_fd_pr__pfet_01v8 ad=0.1218 pd=1.42 as=0.1218 ps=1.42 w=0.42 l=0.15
X35 vdd_capture capture_clk a_1027_36047# vdd_capture sky130_fd_pr__pfet_01v8_hvt ad=0.0864 pd=0.91 as=0.1664 ps=1.8 w=0.64 l=0.15
X36 a_1193_36047# a_1027_36047# vss vss sky130_fd_pr__nfet_01v8 ad=0.1092 pd=1.36 as=0.0567 ps=0.69 w=0.42 l=0.15
X37 vss capture_clk a_1027_36047# vss sky130_fd_pr__nfet_01v8 ad=0.0567 pd=0.69 as=0.1092 ps=1.36 w=0.42 l=0.15
X38 vdd_active out_p out_n vdd_active sky130_fd_pr__pfet_01v8 ad=6.24 pd=10 as=6.72 ps=10.4 w=2.4 l=0.6
X39 latch_sense_p sense_p iso_tail vss sky130_fd_pr__nfet_01v8 ad=3.36 pd=8 as=3.12 ps=7.6 w=1.2 l=0.6
C0 tail vdd_active 1.43419f
C1 a_1027_36047# capture_clk 0.15126f
C2 a_1193_36047# a_1592_36047# 0.00135f
C3 rx_n vdd_capture 0.13066f
C4 out_n vdd 0.76206f
C5 rx_n a_2059_36315# 0.0026f
C6 latch_sense_n vdd_active 1.17466f
C7 a_1027_36047# a_1466_36413# 0.16041f
C8 a_1634_36159# a_2017_36047# 0
C9 a_1027_36047# a_1634_36159# 0.09081f
C10 a_1561_36413# a_1027_36047# 0.0027f
C11 a_1634_36159# a_1466_36413# 0.16113f
C12 rx_n capture_clk 0.01314f
C13 captured_q a_1891_36413# 0.00598f
C14 a_1193_36047# captured_q 0
C15 a_1561_36413# a_1466_36413# 0.00772f
C16 reset vdd 4.03064f
C17 a_1381_36047# a_1193_36047# 0.06685f
C18 a_1634_36159# a_1975_36413# 0.00131f
C19 rx_n a_2017_36047# 0
C20 a_1027_36047# rx_n 0.07135f
C21 sense_n iso_tail 0.03465f
C22 rx_n a_1466_36413# 0.0176f
C23 captured_q vdd_capture 0.14721f
C24 a_1381_36047# vdd_capture 0.0536f
C25 rx_n a_1634_36159# 0.01015f
C26 sense_n latch_sense_n 0.02861f
C27 captured_q a_2059_36315# 0.0652f
C28 out_p out_n 2.57005f
C29 a_1561_36413# rx_n 0
C30 a_1466_36413# a_1592_36047# 0.00553f
C31 tail latch_sense_p 0.0334f
C32 iso_tail latch_sense_p 0.07366f
C33 eq_reset vdd_active 1.50445f
C34 a_1634_36159# a_1592_36047# 0
C35 latch_sense_n latch_sense_p 0.05388f
C36 captured_q capture_clk 0
C37 tail rx_n 0.08768f
C38 out_p vdd_active 3.44635f
C39 out_p reset 0.31048f
C40 captured_q a_2017_36047# 0
C41 rx_n a_1592_36047# 0.00137f
C42 a_1027_36047# captured_q 0
C43 a_1381_36047# a_1027_36047# 0.04548f
C44 captured_q a_1466_36413# 0
C45 a_1381_36047# a_1466_36413# 0.02068f
C46 tail latch_sense_n 0.0334f
C47 latch_sense_n iso_tail 0.07366f
C48 captured_q a_1634_36159# 0.00147f
C49 a_1381_36047# a_1634_36159# 0
C50 a_1561_36413# a_1381_36047# 0.00138f
C51 sense_p latch_sense_p 0.02861f
C52 rx_n vdd 0.08702f
C53 out_n vdd_active 3.49958f
C54 tail vdd 0.94872f
C55 out_n reset 0.31048f
C56 captured_q rx_n 0.0027f
C57 a_1381_36047# rx_n 0.09104f
C58 a_1193_36047# a_1891_36413# 0.1112f
C59 eq_reset latch_sense_p 0.02611f
C60 captured_q a_1592_36047# 0
C61 sense_p iso_tail 0.03465f
C62 a_1891_36413# vdd_capture 0.15692f
C63 a_1193_36047# vdd_capture 0.25974f
C64 out_p latch_sense_p 0.15098f
C65 a_1891_36413# a_2059_36315# 0.20625f
C66 a_1193_36047# a_2059_36315# 0.01914f
C67 out_p rx_n 0.03556f
C68 rx_p out_p 0.05225f
C69 eval rx_n 0
C70 eq_reset latch_sense_n 0.02611f
C71 a_1381_36047# captured_q 0
C72 tail out_p 0.18071f
C73 tail eval 0.09536f
C74 vdd_capture a_2059_36315# 0.32089f
C75 a_1193_36047# capture_clk 0.00591f
C76 a_1891_36413# a_2017_36047# 0.00617f
C77 a_1027_36047# a_1891_36413# 0.03079f
C78 a_1193_36047# a_1027_36047# 0.56916f
C79 a_1193_36047# a_1466_36413# 0.07623f
C80 vdd_capture capture_clk 0.15631f
C81 a_1634_36159# a_1891_36413# 0.0205f
C82 rx_n out_n 0.11016f
C83 a_1891_36413# a_1975_36413# 0.00851f
C84 a_1193_36047# a_1634_36159# 0.08347f
C85 rx_p out_n 0
C86 a_1193_36047# a_1975_36413# 0
C87 vdd_capture a_2017_36047# 0
C88 tail out_n 0.18071f
C89 a_1027_36047# vdd_capture 0.49371f
C90 out_p vdd 0.76206f
C91 vdd_active latch_sense_p 0.91317f
C92 a_2059_36315# a_2017_36047# 0
C93 vdd_capture a_1466_36413# 0.19613f
C94 a_1027_36047# a_2059_36315# 0.02545f
C95 rx_n a_1891_36413# 0.00434f
C96 a_1634_36159# vdd_capture 0.14352f
C97 latch_sense_n out_n 0.15098f
C98 a_1193_36047# rx_n 0.17985f
C99 vdd_capture a_1975_36413# 0.0054f
C100 a_1561_36413# vdd_capture 0.00413f
C101 a_1634_36159# a_2059_36315# 0
C102 rx_n vdd_active 0.25893f
C103 rx_n reset 0.08702f
C104 rx_p vdd_active 0.14036f
C105 iso_tail vss 21.8637f
C106 sense_n vss 1.81302f
C107 sense_p vss 1.81302f
C108 eq_reset vss 0.42287f
C109 latch_sense_n vss 7.80027f
C110 latch_sense_p vss 8.19727f
C111 rx_p vss 0.78388f
C112 out_n vss 21.4637f
C113 out_p vss 21.5448f
C114 reset vss 5.45976f
C115 tail vss 42.1895f
C116 eval vss 1.02146f
C117 captured_q vss 0.29833f
C118 rx_n vss 8.72709f
C119 capture_clk vss 0.35666f
C120 vdd_active vss 0.12589p
C121 vdd vss 69.78f
C122 vdd_capture vss 3.93049f
C123 a_2017_36047# vss 0.0056f ; **FLOATING
C124 a_1592_36047# vss 0.00814f ; **FLOATING
C125 a_1975_36413# vss 0 ; **FLOATING
C126 a_1381_36047# vss 0.04915f ; **FLOATING
C127 a_1891_36413# vss 0.21511f ; **FLOATING
C128 a_2059_36315# vss 0.28086f ; **FLOATING
C129 a_1466_36413# vss 0.15975f ; **FLOATING
C130 a_1634_36159# vss 0.19161f ; **FLOATING
C131 a_1193_36047# vss 0.32958f ; **FLOATING
C132 a_1027_36047# vss 0.44216f ; **FLOATING
.ends
