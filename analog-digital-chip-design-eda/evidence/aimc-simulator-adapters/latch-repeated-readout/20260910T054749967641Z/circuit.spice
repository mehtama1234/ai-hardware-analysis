* NGSPICE file created from combined_latch_receiver.ext - technology: sky130A

.subckt combined_latch_receiver out_p out_n latch_sense_p latch_sense_n tail reset
+ vdd vss eval sense_p sense_n iso_tail vdd_active rx_p rx_n
X0 rx_p out_p vss vss sky130_fd_pr__nfet_01v8 ad=0.1218 pd=1.42 as=0.1218 ps=1.42 w=0.42 l=0.15
X1 out_p out_n vdd_active vdd_active sky130_fd_pr__pfet_01v8 ad=6.72 pd=10.4 as=6.24 ps=10 w=2.4 l=0.6
X2 vss out_n rx_n vss sky130_fd_pr__nfet_01v8 ad=0.1218 pd=1.42 as=0.1218 ps=1.42 w=0.42 l=0.15
X3 vdd reset out_n vdd sky130_fd_pr__pfet_01v8 ad=3.12 pd=7.6 as=3.36 ps=8 w=1.2 l=0.6
X4 tail out_p out_n vss sky130_fd_pr__nfet_01v8 ad=3.12 pd=7.6 as=3.36 ps=8 w=1.2 l=0.6
X5 out_p reset vdd vdd sky130_fd_pr__pfet_01v8 ad=3.36 pd=8 as=3.12 ps=7.6 w=1.2 l=0.6
X6 out_p out_n tail vss sky130_fd_pr__nfet_01v8 ad=3.36 pd=8 as=3.12 ps=7.6 w=1.2 l=0.6
X7 tail latch_sense_n out_n vss sky130_fd_pr__nfet_01v8 ad=3.12 pd=7.6 as=3.36 ps=8 w=1.2 l=0.6
X8 tail eval vss vss sky130_fd_pr__nfet_01v8 ad=16.2 pd=17.4 as=16.2 ps=17.4 w=6 l=0.6
X9 out_p latch_sense_p tail vss sky130_fd_pr__nfet_01v8 ad=3.36 pd=8 as=3.12 ps=7.6 w=1.2 l=0.6
X10 iso_tail sense_n latch_sense_n vss sky130_fd_pr__nfet_01v8 ad=3.12 pd=7.6 as=3.36 ps=8 w=1.2 l=0.6
X11 rx_p out_p vdd_active vdd_active sky130_fd_pr__pfet_01v8 ad=0.1218 pd=1.42 as=0.1218 ps=1.42 w=0.42 l=0.15
X12 vdd_active out_n rx_n vdd_active sky130_fd_pr__pfet_01v8 ad=0.1218 pd=1.42 as=0.1218 ps=1.42 w=0.42 l=0.15
X13 vdd_active out_p out_n vdd_active sky130_fd_pr__pfet_01v8 ad=6.24 pd=10 as=6.72 ps=10.4 w=2.4 l=0.6
X14 latch_sense_p sense_p iso_tail vss sky130_fd_pr__nfet_01v8 ad=3.36 pd=8 as=3.12 ps=7.6 w=1.2 l=0.6
C0 out_p reset 0.31048f
C1 vdd tail 0.94872f
C2 out_n latch_sense_n 0.15098f
C3 iso_tail sense_n 0.03465f
C4 out_p tail 0.18071f
C5 latch_sense_p iso_tail 0.07366f
C6 tail eval 0.09538f
C7 out_n rx_n 0.05069f
C8 vdd_active rx_n 0.14036f
C9 latch_sense_n tail 0.0334f
C10 out_n vdd_active 3.49958f
C11 iso_tail sense_p 0.03465f
C12 out_n vdd 0.76206f
C13 out_p rx_n 0.00223f
C14 out_n rx_p 0
C15 out_p out_n 2.57005f
C16 vdd_active rx_p 0.14036f
C17 out_n reset 0.31048f
C18 latch_sense_p out_p 0.15098f
C19 out_p vdd_active 3.44635f
C20 iso_tail latch_sense_n 0.07366f
C21 out_n tail 0.18071f
C22 latch_sense_p sense_p 0.02861f
C23 latch_sense_p tail 0.0334f
C24 vdd_active tail 1.43419f
C25 out_p vdd 0.76206f
C26 out_p rx_p 0.05225f
C27 vdd reset 4.03064f
C28 sense_n latch_sense_n 0.02861f
C29 iso_tail vss 21.8637f
C30 sense_n vss 1.81302f
C31 sense_p vss 1.81302f
C32 latch_sense_n vss 7.56409f
C33 latch_sense_p vss 7.56409f
C34 rx_n vss 0.78574f
C35 rx_p vss 0.78388f
C36 out_n vss 21.5282f
C37 out_p vss 21.5529f
C38 reset vss 5.47359f
C39 tail vss 42.2044f
C40 eval vss 1.02146f
C41 vdd_active vss 82.4774f
C42 vdd vss 69.79389f
.ends
