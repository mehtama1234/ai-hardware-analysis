* NGSPICE file created from combined_latch_receiver.ext - technology: sky130A

.subckt combined_latch_receiver out_p out_n latch_sense_p latch_sense_n tail reset
+ vdd vss eval sense_p sense_n iso_tail vdd_active rx_p rx_n eq_reset
X0 rx_p out_p vss vss sky130_fd_pr__nfet_01v8 ad=0.1218 pd=1.42 as=0.1218 ps=1.42 w=0.42 l=0.15
X1 out_p out_n vdd_active vdd_active sky130_fd_pr__pfet_01v8 ad=6.72 pd=10.4 as=6.24 ps=10 w=2.4 l=0.6
X2 vss out_n rx_n vss sky130_fd_pr__nfet_01v8 ad=0.1218 pd=1.42 as=0.1218 ps=1.42 w=0.42 l=0.15
X3 latch_sense_n eq_reset latch_sense_p vdd_active sky130_fd_pr__pfet_01v8 ad=3.24 pd=7.8 as=3.24 ps=7.8 w=1.2 l=0.6
X4 vdd reset out_n vdd sky130_fd_pr__pfet_01v8 ad=3.12 pd=7.6 as=3.36 ps=8 w=1.2 l=0.6
X5 tail out_p out_n vss sky130_fd_pr__nfet_01v8 ad=3.12 pd=7.6 as=3.36 ps=8 w=1.2 l=0.6
X6 out_p reset vdd vdd sky130_fd_pr__pfet_01v8 ad=3.36 pd=8 as=3.12 ps=7.6 w=1.2 l=0.6
X7 out_p out_n tail vss sky130_fd_pr__nfet_01v8 ad=3.36 pd=8 as=3.12 ps=7.6 w=1.2 l=0.6
X8 tail latch_sense_n out_n vss sky130_fd_pr__nfet_01v8 ad=3.12 pd=7.6 as=3.36 ps=8 w=1.2 l=0.6
X9 tail eval vss vss sky130_fd_pr__nfet_01v8 ad=16.2 pd=17.4 as=16.2 ps=17.4 w=6 l=0.6
X10 out_p latch_sense_p tail vss sky130_fd_pr__nfet_01v8 ad=3.36 pd=8 as=3.12 ps=7.6 w=1.2 l=0.6
X11 iso_tail sense_n latch_sense_n vss sky130_fd_pr__nfet_01v8 ad=3.12 pd=7.6 as=3.36 ps=8 w=1.2 l=0.6
X12 rx_p out_p vdd_active vdd_active sky130_fd_pr__pfet_01v8 ad=0.1218 pd=1.42 as=0.1218 ps=1.42 w=0.42 l=0.15
X13 vdd_active out_n rx_n vdd_active sky130_fd_pr__pfet_01v8 ad=0.1218 pd=1.42 as=0.1218 ps=1.42 w=0.42 l=0.15
X14 vdd_active out_p out_n vdd_active sky130_fd_pr__pfet_01v8 ad=6.24 pd=10 as=6.72 ps=10.4 w=2.4 l=0.6
X15 latch_sense_p sense_p iso_tail vss sky130_fd_pr__nfet_01v8 ad=3.36 pd=8 as=3.12 ps=7.6 w=1.2 l=0.6
C0 latch_sense_p iso_tail 0.07366f
C1 eq_reset latch_sense_p 0.02611f
C2 out_p latch_sense_p 0.15098f
C3 sense_p iso_tail 0.03465f
C4 iso_tail sense_n 0.03465f
C5 out_p out_n 2.57005f
C6 latch_sense_n tail 0.0334f
C7 vdd_active tail 1.43419f
C8 eval tail 0.09538f
C9 rx_n out_n 0.05069f
C10 vdd out_n 0.76206f
C11 latch_sense_n vdd_active 1.17466f
C12 vdd_active rx_p 0.14036f
C13 latch_sense_p tail 0.0334f
C14 reset out_n 0.31048f
C15 latch_sense_n latch_sense_p 0.05388f
C16 rx_n out_p 0.00223f
C17 latch_sense_p vdd_active 0.91317f
C18 tail out_n 0.18071f
C19 out_p vdd 0.76206f
C20 latch_sense_n out_n 0.15098f
C21 vdd_active out_n 3.49958f
C22 rx_p out_n 0
C23 latch_sense_n sense_n 0.02861f
C24 reset out_p 0.31048f
C25 latch_sense_n iso_tail 0.07366f
C26 out_p tail 0.18071f
C27 latch_sense_n eq_reset 0.02611f
C28 eq_reset vdd_active 1.50445f
C29 reset vdd 4.03064f
C30 sense_p latch_sense_p 0.02861f
C31 out_p vdd_active 3.44635f
C32 out_p rx_p 0.05225f
C33 vdd tail 0.94872f
C34 rx_n vdd_active 0.14036f
C35 iso_tail vss 21.8637f
C36 sense_n vss 1.81302f
C37 sense_p vss 1.81302f
C38 eq_reset vss 0.42287f
C39 latch_sense_n vss 7.80027f
C40 latch_sense_p vss 8.19727f
C41 rx_n vss 0.78574f
C42 rx_p vss 0.78388f
C43 out_n vss 21.5282f
C44 out_p vss 21.5529f
C45 reset vss 5.47359f
C46 tail vss 42.2044f
C47 eval vss 1.02146f
C48 vdd_active vss 0.1259p
C49 vdd vss 69.79389f
.ends
