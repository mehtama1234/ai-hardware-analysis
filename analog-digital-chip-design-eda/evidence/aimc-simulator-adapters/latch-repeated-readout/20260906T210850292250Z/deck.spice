* Signed small-signal extracted latch diagnostic, no structural MOS substitution.
.option scale=1u
.param mc_mm_switch=1 mc_pr_switch=0
.include "/home/mehtama1/eda-tools/pdks/sky130A/libs.ref/sky130_fd_pr/spice/sky130_fd_pr__nfet_01v8__tt.pm3.spice"
.include "/home/mehtama1/eda-tools/pdks/sky130A/libs.ref/sky130_fd_pr/spice/sky130_fd_pr__nfet_01v8__mismatch.corner.spice"
.include "/home/mehtama1/eda-tools/pdks/sky130A/libs.ref/sky130_fd_pr/spice/sky130_fd_pr__pfet_01v8__tt.corner.spice"
.include "/home/mehtama1/eda-tools/pdks/sky130A/libs.ref/sky130_fd_pr/spice/sky130_fd_pr__pfet_01v8__mismatch.corner.spice"
* SKY130 Spice File.
.option scale=1.0u
.include "/home/mehtama1/eda-tools/pdks/sky130A/libs.tech/ngspice/parameters/lod.spice"
.param
+ lv_dlc_rotweak = .00e-9
+ lvhvt_dlc_rotweak = .00e-9
+ lvt_dlc_rotweak = .00e-9
+ hv_dlc_rotweak = .00e-9
+ sky130_fd_pr__nfet_01v8__dlc_rotweak = lv_dlc_rotweak
+ sky130_fd_pr__esd_nfet_01v8__dlc_rotweak = lv_dlc_rotweak
+ sky130_fd_pr__nfet_01v8_lvt__dlc_rotweak = lvt_dlc_rotweak
+ sky130_fd_pr__pfet_01v8__dlc_rotweak = lv_dlc_rotweak
+ sky130_fd_pr__pfet_01v8_lvt__dlc_rotweak = lvt_dlc_rotweak
+ sky130_fd_pr__pfet_01v8_hvt__dlc_rotweak = lvhvt_dlc_rotweak
+ sky130_fd_pr__esd_nfet_g5v0d10v5__dlc_rotweak = hv_dlc_rotweak
+ sky130_fd_pr__esd_pfet_g5v0d10v5__dlc_rotweak = hv_dlc_rotweak
+ sky130_fd_pr__nfet_03v3_nvt__dlc_rotweak = hv_dlc_rotweak
+ sky130_fd_pr__nfet_05v0_nvt__dlc_rotweak = hv_dlc_rotweak
+ sky130_fd_pr__nfet_g5v0d10v5__dlc_rotweak = hv_dlc_rotweak
+ sky130_fd_pr__pfet_g5v0d10v5__dlc_rotweak = hv_dlc_rotweak
+ sky130_fd_pr__pfet_g5v0d16v0__dlc_rotweak = hv_dlc_rotweak
+ sky130_fd_pr__special_nfet_pass__dlc_rotweak = lv_dlc_rotweak
+ sky130_fd_pr__special_nfet_pass_lowleakage__dlc_rotweak = lv_dlc_rotweak
+ sky130_fd_pr__special_nfet_pass_flash__dlc_rotweak = hv_dlc_rotweak
+ sky130_fd_pr__special_nfet_latch__dlc_rotweak = lv_dlc_rotweak
+ sky130_fd_pr__special_nfet_latch_lowleakage__dlc_rotweak = lv_dlc_rotweak
+ sky130_fd_pr__special_pfet_latch__dlc_rotweak = lv_dlc_rotweak
+ sky130_fd_pr__special_pfet_latch_lowleakage__dlc_rotweak = lv_dlc_rotweak
+ sky130_fd_bs_flash__special_sonosfet_star__dlc_rotweak = hv_dlc_rotweak
+ sky130_fd_bs_flash__special_sonosfet_original__dlc_rotweak = hv_dlc_rotweak
+ sonos_eeol_dlc_rotweak = hv_dlc_rotweak
+ sonos_peol_dlc_rotweak = hv_dlc_rotweak

.include "/home/mehtama1/git-repo/ai-hardware-analysis/analog-digital-chip-design-eda/evidence/aimc-simulator-adapters/latch-repeated-readout/20260906T210850292250Z/circuit.spice"
.temp 27
.options method=gear reltol=1e-05 abstol=1e-14 vntol=1e-7
VDD vdd 0 1.75
VACTIVE vdd_active 0 1.8
VSS vss 0 0
VP sense_p 0 PWL(0n 0.9055 95n 0.9055 95.02n 0.9060625 195n 0.9060625 195.02n 0.9075 295n 0.9075 295.02n 0.9060625 395n 0.9060625 395.02n 0.9055 495n 0.9055 495.02n 0.906125 595n 0.906125 595.02n 0.9075 695n 0.9075 695.02n 0.906125 795n 0.906125 795.02n 0.9055 895n 0.9055 895.02n 0.9061875 995n 0.9061875 995.02n 0.9075 1095n 0.9075 1095.02n 0.9061875)
VN sense_n 0 PWL(0n 0.8945 95n 0.8945 95.02n 0.8939375 195n 0.8939375 195.02n 0.8925 295n 0.8925 295.02n 0.8939375 395n 0.8939375 395.02n 0.8945 495n 0.8945 495.02n 0.893875 595n 0.893875 595.02n 0.8925 695n 0.8925 695.02n 0.893875 795n 0.893875 795.02n 0.8945 895n 0.8945 895.02n 0.8938125 995n 0.8938125 995.02n 0.8925 1095n 0.8925 1095.02n 0.8938125)
IBIAS iso_tail 0 4u
RP vdd_active latch_sense_p 350000
RN vdd_active latch_sense_n 350000
VRESET reset 0 PULSE(0 1.75 8n 20p 1000p 29.5n 100n)
VEVAL eval 0 PULSE(0 1.8 7.8n 20p 1000p 30n 100n)
XU out_p out_n latch_sense_p latch_sense_n tail reset vdd vss eval sense_p sense_n iso_tail vdd_active rx_p rx_n combined_latch_receiver

CRXp rx_p vss 2f
CRXn rx_n vss 2f
.tran 20p 1200n 0 5p
.measure tran op_final FIND v(out_p) AT=18n
.measure tran on_final FIND v(out_n) AT=18n
.measure tran lp_before FIND v(latch_sense_p) AT=7.6n
.measure tran ln_before FIND v(latch_sense_n) AT=7.6n
.control
setseed 102
reset
run
write waveform.raw v(out_p) v(out_n) v(latch_sense_p) v(latch_sense_n) v(iso_tail) v(tail) v(reset) v(eval) i(vdd) i(vactive) v(rx_p) v(rx_n)
.endc
.end
