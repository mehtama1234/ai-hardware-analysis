* NGSPICE file created from aimc_converter_macro.ext - technology: sky130A

.subckt aimc_converter_macro vss vdd row_drive column_sense digital_code_out sample_clock
C0 row_drive column_sense 0.08871f
C1 digital_code_out row_drive 0.00852f
C2 sample_clock column_sense 0.00493f
C3 digital_code_out sample_clock 0.02344f
C4 digital_code_out column_sense 0.29672f
C5 vss vdd 0.4479f
C6 vss row_drive 0.48996f
C7 vss sample_clock 0.2174f
C8 row_drive vdd 0.25431f
C9 vss column_sense 0.25253f
C10 digital_code_out vss 0.3288f
C11 sample_clock vdd 0.37987f
C12 column_sense vdd 0.29373f
C13 digital_code_out vdd 0.70889f
C14 vss VSUBS 2.74134f
C15 digital_code_out VSUBS 1.20105f
C16 row_drive VSUBS 1.09469f
C17 sample_clock VSUBS 0.74026f
C18 column_sense VSUBS 1.15836f
C19 vdd VSUBS 2.56389f
.ends
