* NGSPICE file created from shared_converter_mux.ext - technology: sky130A

.subckt shared_converter_mux vss mux_bus vdd
C0 mux_bus vdd 1.55306f
C1 mux_bus vss 1.56188f
C2 vss VSUBS 1.39454f
C3 mux_bus VSUBS 3.03532f
C4 vdd VSUBS 1.41225f
.ends
