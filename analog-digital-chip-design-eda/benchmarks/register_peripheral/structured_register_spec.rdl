addrmap peripheral {
  reg status @0x0 {
    field { sw = r; reset = 1; } ready[0:0];
    field { sw = rw; reset = 0; } enable[1:1];
  };
  reg events {
    field { sw = rw; onwrite = wclr; } error[0:0];
  };
};
