* NGSPICE file created from aimc_converter_macro_active_candidate_flat_parallel.ext - technology: sky130A

.subckt aimc_converter_macro_active_candidate_flat_parallel vss vdd row_drive sar_comparator_input
+ decision_p decision_n reset eval vss_escape latch_sense_p_ext latch_sense_n_ext
+ iso_tail_ext tail_ext vdd_ext preamp_iso_tail_ext
X0 latch_sense_n_ext a_51120_36400# preamp_iso_tail_ext vss_escape sky130_fd_pr__nfet_01v8 ad=3.36 pd=8 as=3.12 ps=7.6 w=1.2 l=0.6
X1 latch_sense_p_ext a_46720_36400# preamp_iso_tail_ext vss_escape sky130_fd_pr__nfet_01v8 ad=3.36 pd=8 as=3.12 ps=7.6 w=1.2 l=0.6
X2 vdd_ext decision_p decision_n vdd_ext sky130_fd_pr__pfet_01v8 ad=3.12 pd=7.6 as=3.36 ps=8 w=1.2 l=0.6
X3 tail_ext eval vss_escape vss_escape sky130_fd_pr__nfet_01v8 ad=16.2 pd=17.4 as=16.2 ps=17.4 w=6 l=0.6
X4 latch_sense_n_ext a_52720_36400# preamp_iso_tail_ext vss_escape sky130_fd_pr__nfet_01v8 ad=3.36 pd=8 as=3.12 ps=7.6 w=1.2 l=0.6
X5 decision_p latch_sense_p_ext tail_ext vss_escape sky130_fd_pr__nfet_01v8 ad=3.36 pd=8 as=3.12 ps=7.6 w=1.2 l=0.6
X6 vdd_ext reset decision_n vdd_ext sky130_fd_pr__pfet_01v8 ad=3.12 pd=7.6 as=3.36 ps=8 w=1.2 l=0.6
X7 tail_ext latch_sense_n_ext decision_n vss_escape sky130_fd_pr__nfet_01v8 ad=3.12 pd=7.6 as=3.36 ps=8 w=1.2 l=0.6
X8 decision_p decision_n vdd_ext vdd_ext sky130_fd_pr__pfet_01v8 ad=3.36 pd=8 as=3.12 ps=7.6 w=1.2 l=0.6
X9 tail_ext decision_p decision_n vss_escape sky130_fd_pr__nfet_01v8 ad=3.12 pd=7.6 as=3.36 ps=8 w=1.2 l=0.6
X10 latch_sense_p_ext row_drive iso_tail_ext vss_escape sky130_fd_pr__nfet_01v8 ad=3.36 pd=8 as=3.12 ps=7.6 w=1.2 l=0.6
X11 iso_tail_ext sar_comparator_input latch_sense_n_ext vss_escape sky130_fd_pr__nfet_01v8 ad=3.12 pd=7.6 as=3.36 ps=8 w=1.2 l=0.6
X12 latch_sense_p_ext a_45120_36400# preamp_iso_tail_ext vss_escape sky130_fd_pr__nfet_01v8 ad=3.36 pd=8 as=3.12 ps=7.6 w=1.2 l=0.6
X13 decision_p reset vdd_ext vdd_ext sky130_fd_pr__pfet_01v8 ad=3.36 pd=8 as=3.12 ps=7.6 w=1.2 l=0.6
X14 decision_p decision_n tail_ext vss_escape sky130_fd_pr__nfet_01v8 ad=3.36 pd=8 as=3.12 ps=7.6 w=1.2 l=0.6
C0 vss shared_converter_mux_0.mux_bus 0.03132f
C1 latch_sense_n_ext vdd_ext 4.56493f
C2 reset vdd_ext 4.48789f
C3 vdd_ext sar_readout_12b_0.vss 0.93663f
C4 preamp_iso_tail_ext a_52720_36400# 0.04002f
C5 sar_readout_12b_0.vdd sar_readout_12b_0.vss 0.49712f
C6 row_drive sar_comparator_input 5.49941f
C7 sar_comparator_input a_46720_36400# 0.0189f
C8 latch_sense_n_ext iso_tail_ext 0.12999f
C9 vss latch_sense_n_ext 0.29037f
C10 decision_n sar_comparator_input 0.17131f
C11 row_drive m4_45060_36440# 0.09725f
C12 iso_tail_ext sar_readout_12b_0.vss 0.60045f
C13 a_51120_36400# vdd_ext 0.00487f
C14 a_46720_36400# m4_45060_36440# 0
C15 m1_68300_3080# sar_comparator_input 0.05195f
C16 sar_comparator_input a_52720_36400# 0.11162f
C17 latch_sense_n_ext tail_ext 1.09601f
C18 reset tail_ext 0.17577f
C19 row_drive a_46720_36400# 0.11052f
C20 latch_sense_p_ext preamp_iso_tail_ext 0.65876f
C21 latch_sense_p_ext a_45120_36400# 0.07133f
C22 row_drive shared_converter_mux_0.vss 0.00246f
C23 row_drive m1_68300_3080# 2.68328f
C24 shared_converter_mux_0.vdd vdd_ext 0
C25 preamp_iso_tail_ext vdd_ext 0.06104f
C26 a_45120_36400# vdd_ext 0.00411f
C27 eval latch_sense_p_ext 0.19752f
C28 latch_sense_p_ext sar_comparator_input 0.11023f
C29 eval vdd_ext 0
C30 vss shared_converter_mux_0.vdd 0.2816f
C31 latch_sense_p_ext m4_45060_36440# 0.00631f
C32 sar_comparator_input vdd_ext 1.76746f
C33 latch_sense_n_ext a_51120_36400# 0.07662f
C34 latch_sense_p_ext m4_32000_38940# 0.00354f
C35 row_drive row_dac_10b_0.vss 1.08123f
C36 vdd_ext m4_45060_36440# 0.01404f
C37 decision_p decision_n 2.54301f
C38 sar_comparator_input iso_tail_ext 0.16721f
C39 row_drive latch_sense_p_ext 1.28458f
C40 shared_converter_mux_0.mux_bus shared_converter_mux_0.vdd 1.55306f
C41 latch_sense_p_ext a_46720_36400# 0.06268f
C42 vss sar_comparator_input 0.05708f
C43 eval tail_ext 0.36751f
C44 row_drive vdd_ext 5.08043f
C45 vdd row_drive 0.1964f
C46 row_drive sar_readout_12b_0.vdd 0.58157f
C47 a_46720_36400# vdd_ext 0.00945f
C48 row_drive m2_42000_41940# 0.12051f
C49 decision_n vdd_ext 3.9382f
C50 latch_sense_n_ext preamp_iso_tail_ext 0.66393f
C51 shared_converter_mux_0.vss vdd_ext 0
C52 latch_sense_n_ext a_45120_36400# 0.01895f
C53 row_drive iso_tail_ext 2.39704f
C54 m1_68300_3080# vdd_ext 0.24419f
C55 vss row_drive 0.22445f
C56 a_52720_36400# vdd_ext 0.00945f
C57 decision_p latch_sense_p_ext 0.37635f
C58 row_drive row_dac_10b_0.vdd 1.11462f
C59 a_51120_36400# preamp_iso_tail_ext 0.1436f
C60 latch_sense_n_ext sar_comparator_input 0.64528f
C61 decision_n tail_ext 0.48065f
C62 row_drive shared_converter_mux_0.mux_bus 0.06281f
C63 decision_p vdd_ext 3.8282f
C64 latch_sense_n_ext m4_32000_38940# 0.0096f
C65 shared_converter_mux_0.vss shared_converter_mux_0.mux_bus 1.56188f
C66 sar_comparator_input a_51120_36400# 0.15479f
C67 latch_sense_p_ext vdd_ext 5.39204f
C68 row_drive latch_sense_n_ext 0.79974f
C69 latch_sense_n_ext a_46720_36400# 0.02118f
C70 row_drive sar_readout_12b_0.vss 0.29433f
C71 sar_readout_12b_0.vdd vdd_ext 1.39936f
C72 latch_sense_n_ext decision_n 0.37635f
C73 a_45120_36400# preamp_iso_tail_ext 0.15424f
C74 latch_sense_p_ext iso_tail_ext 0.1295f
C75 decision_p tail_ext 0.48065f
C76 vss latch_sense_p_ext 0.29037f
C77 decision_n reset 0.31048f
C78 row_dac_10b_0.vss row_dac_10b_0.vdd 0.78467f
C79 latch_sense_n_ext a_52720_36400# 0.08882f
C80 iso_tail_ext vdd_ext 0.86179f
C81 sar_readout_12b_0.vdd iso_tail_ext 0.27521f
C82 latch_sense_p_ext tail_ext 0.99589f
C83 vss vdd_ext 0.19458f
C84 sar_comparator_input preamp_iso_tail_ext 0.14257f
C85 a_45120_36400# sar_comparator_input 0.01601f
C86 tail_ext vdd_ext 1.9856f
C87 preamp_iso_tail_ext m4_45060_36440# 0.00188f
C88 a_51120_36400# a_52720_36400# 0.01036f
C89 a_45120_36400# m4_45060_36440# 0.00936f
C90 decision_p reset 0.376f
C91 shared_converter_mux_0.mux_bus vdd_ext 0.00217f
C92 row_drive shared_converter_mux_0.vdd 0.00246f
C93 latch_sense_n_ext latch_sense_p_ext 0.69337f
C94 row_drive preamp_iso_tail_ext 0.05076f
C95 a_46720_36400# preamp_iso_tail_ext 0.05066f
C96 sar_comparator_input m4_45060_36440# 0.05954f
C97 row_drive a_45120_36400# 0.13165f
C98 latch_sense_p_ext reset 0.19529f
C99 a_45120_36400# a_46720_36400# 0.01036f
C100 vss vss_escape 36.2394f
C101 vdd vss_escape 36.7f
C102 iso_tail_ext vss_escape 93.4636f
C103 decision_p vss_escape 12.48503f
C104 tail_ext vss_escape 0.1231p
C105 latch_sense_n_ext vss_escape 18.0554f
C106 latch_sense_p_ext vss_escape 55.2592f
C107 preamp_iso_tail_ext vss_escape 9.8422f
C108 vdd_ext vss_escape 0.25966p
C109 m4_45060_36440# vss_escape 0.0768f ; **FLOATING
C110 m4_32000_38940# vss_escape 0.1568f ; **FLOATING
C111 m2_42000_41940# vss_escape 3.91591f ; **FLOATING
C112 sar_readout_12b_0.vss vss_escape 1.33686f ; **FLOATING
C113 row_dac_10b_0.vss vss_escape 1.40333f ; **FLOATING
C114 row_dac_10b_0.vdd vss_escape 1.33457f ; **FLOATING
C115 sar_readout_12b_0.vdd vss_escape 1.77614f ; **FLOATING
C116 m1_68300_3080# vss_escape 7.89552f ; **FLOATING
C117 shared_converter_mux_0.vss vss_escape 1.39454f ; **FLOATING
C118 shared_converter_mux_0.mux_bus vss_escape 2.86922f ; **FLOATING
C119 shared_converter_mux_0.vdd vss_escape 0.95985f ; **FLOATING
.ends
