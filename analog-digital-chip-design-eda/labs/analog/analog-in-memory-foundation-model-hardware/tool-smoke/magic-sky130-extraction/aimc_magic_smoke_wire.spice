* NGSPICE file created from aimc_magic_smoke_wire.ext - technology: sky130A

.subckt aimc_magic_smoke_wire smoke_node
C0 smoke_node VSUBS 0.21536f
.ends
