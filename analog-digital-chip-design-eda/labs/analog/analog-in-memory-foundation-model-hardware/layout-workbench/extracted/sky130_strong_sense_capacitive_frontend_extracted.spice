* NGSPICE file created from sky130_strong_sense_capacitive_frontend.ext - technology: sky130A

.subckt sky130_strong_sense_capacitive_frontend vss vdd sample_p sense_p clk_sample
+ vcm_reset clk_latch sense_n sample_n
C0 vcm_reset strong_sample_p_sense_p_region 0
C1 strong_sample_n_sense_n_region vcm_reset 0
C2 sense_n strong_sample_n_sense_n_region 0.84116f
C3 vdd clk_sample 0.22966f
C4 sense_p symmetric_reset_region 0
C5 vdd strong_sample_p_sense_p_region 0.02168f
C6 vdd strong_sample_n_sense_n_region 0.02168f
C7 sample_n symmetric_reset_region 0
C8 clk_latch symmetric_latch_clock_region 0.3313f
C9 vss vcm_reset 0.22331f
C10 sense_n vss 0.20663f
C11 sample_p symmetric_reset_region 0
C12 strong_sample_n_sense_n_region clk_latch 0.00393f
C13 sample_p sense_p 0.46429f
C14 symmetric_latch_clock_region symmetric_reset_region 0.04332f
C15 vdd vcm_reset 0.22427f
C16 sense_n vdd 0.20663f
C17 sense_p symmetric_latch_clock_region 0
C18 sample_n symmetric_latch_clock_region 0
C19 vss clk_latch 0.22956f
C20 clk_sample symmetric_reset_region 0.33089f
C21 sense_p clk_sample 0.04851f
C22 symmetric_reset_region strong_sample_p_sense_p_region 0.00544f
C23 strong_sample_n_sense_n_region symmetric_reset_region 0.00544f
C24 sense_p strong_sample_p_sense_p_region 0.84116f
C25 clk_latch vcm_reset 0.1413f
C26 sense_n clk_latch 0.04851f
C27 sample_p symmetric_latch_clock_region 0
C28 sample_n strong_sample_n_sense_n_region 0.74486f
C29 vdd clk_latch 0.23051f
C30 vss sense_p 0.20663f
C31 sample_p strong_sample_p_sense_p_region 0.74486f
C32 sample_n vss 0.20194f
C33 clk_sample symmetric_latch_clock_region 0.32993f
C34 vcm_reset symmetric_reset_region 0.36958f
C35 sense_n symmetric_reset_region 0
C36 symmetric_latch_clock_region strong_sample_p_sense_p_region 0.00181f
C37 strong_sample_n_sense_n_region symmetric_latch_clock_region 0.00181f
C38 sample_n sense_n 0.46429f
C39 sample_p vss 0.20194f
C40 vdd symmetric_reset_region 0.04616f
C41 clk_sample strong_sample_p_sense_p_region 0.00393f
C42 vdd sense_p 0.20663f
C43 sample_n vdd 0.20194f
C44 vss symmetric_latch_clock_region 0.06258f
C45 clk_latch symmetric_reset_region 0.33225f
C46 vss clk_sample 0.2287f
C47 sample_p vdd 0.20194f
C48 vcm_reset symmetric_latch_clock_region 0.36862f
C49 sense_n symmetric_latch_clock_region 0
C50 vss strong_sample_p_sense_p_region 0.02168f
C51 vss strong_sample_n_sense_n_region 0.02168f
C52 clk_sample vcm_reset 0.15476f
C53 sample_n VSUBS 0.57786f
C54 sense_n VSUBS 0.38597f
C55 clk_latch VSUBS 0.52437f
C56 vcm_reset VSUBS 0.34713f
C57 clk_sample VSUBS 0.51527f
C58 sense_p VSUBS 0.38597f
C59 sample_p VSUBS 0.57786f
C60 vss VSUBS 2.63807f
C61 vdd VSUBS 2.66522f
C62 strong_sample_n_sense_n_region VSUBS 0.94013f ; **FLOATING
C63 symmetric_latch_clock_region VSUBS 0.6827f ; **FLOATING
C64 symmetric_reset_region VSUBS 0.69336f ; **FLOATING
C65 strong_sample_p_sense_p_region VSUBS 0.94013f ; **FLOATING
.ends
