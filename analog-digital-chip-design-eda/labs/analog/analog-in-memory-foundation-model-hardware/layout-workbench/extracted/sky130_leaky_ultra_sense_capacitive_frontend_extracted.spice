* NGSPICE file created from sky130_leaky_ultra_sense_capacitive_frontend.ext - technology: sky130A

.subckt sky130_leaky_ultra_sense_capacitive_frontend vss vdd sample_p sense_p clk_sample
+ vcm_reset clk_latch sense_n sample_n ultra_sample_p_sense_p_region ultra_sample_n_sense_n_region
+ symmetric_reset_region symmetric_latch_clock_region
C0 symmetric_latch_clock_region vcm_reset 0.46074f
C1 vss sense_p 0.19187f
C2 ultra_sample_n_sense_n_region vdd 0.05867f
C3 sense_n ultra_sample_n_sense_n_region 1.69268f
C4 sense_p ultra_sample_p_sense_p_region 1.69268f
C5 clk_sample vdd 0.23373f
C6 clk_latch vdd 0.23373f
C7 symmetric_reset_region ultra_sample_p_sense_p_region 0.00907f
C8 vss ultra_sample_n_sense_n_region 0.05867f
C9 sample_n ultra_sample_n_sense_n_region 1.54805f
C10 vss clk_sample 0.23373f
C11 vss clk_latch 0.23373f
C12 vcm_reset vdd 0.23025f
C13 vss symmetric_latch_clock_region 0.05101f
C14 clk_sample ultra_sample_p_sense_p_region 0.01482f
C15 ultra_sample_n_sense_n_region symmetric_reset_region 0.00907f
C16 symmetric_latch_clock_region ultra_sample_p_sense_p_region 0.00907f
C17 vss vcm_reset 0.23025f
C18 symmetric_reset_region clk_sample 0.37954f
C19 clk_latch symmetric_reset_region 0.37954f
C20 sample_p vdd 0.18668f
C21 symmetric_latch_clock_region symmetric_reset_region 0.04571f
C22 sense_n vdd 0.19187f
C23 clk_latch ultra_sample_n_sense_n_region 0.01482f
C24 ultra_sample_n_sense_n_region symmetric_latch_clock_region 0.00907f
C25 symmetric_reset_region vcm_reset 0.46074f
C26 vss sample_p 0.18668f
C27 sense_n vss 0.19187f
C28 sample_n vdd 0.18668f
C29 sample_n sense_n 0.8f
C30 ultra_sample_p_sense_p_region vdd 0.05867f
C31 symmetric_latch_clock_region clk_sample 0.37954f
C32 clk_latch symmetric_latch_clock_region 0.37954f
C33 sample_p ultra_sample_p_sense_p_region 1.54805f
C34 sense_p vdd 0.19187f
C35 sample_p sense_p 0.8f
C36 sample_n vss 0.18668f
C37 symmetric_reset_region vdd 0.05101f
C38 vcm_reset clk_sample 0.125f
C39 clk_latch vcm_reset 0.125f
C40 vss ultra_sample_p_sense_p_region 0.05867f
C41 sample_n VSUBS 0.60102f
C42 sense_n VSUBS 0.41655f
C43 clk_latch VSUBS 0.8327f
C44 vcm_reset VSUBS 0.53148f
C45 clk_sample VSUBS 0.8327f
C46 sense_p VSUBS 0.41655f
C47 sample_p VSUBS 0.60102f
C48 vss VSUBS 3.15132f
C49 ultra_sample_n_sense_n_region VSUBS 2.56515f
C50 symmetric_latch_clock_region VSUBS 0.96795f
C51 symmetric_reset_region VSUBS 0.96795f
C52 ultra_sample_p_sense_p_region VSUBS 2.56515f
C53 vdd VSUBS 3.15132f
.ends
