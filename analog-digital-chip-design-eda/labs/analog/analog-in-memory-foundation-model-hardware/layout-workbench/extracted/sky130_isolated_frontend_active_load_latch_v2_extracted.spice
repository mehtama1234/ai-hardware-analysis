* NGSPICE file created from sky130_isolated_frontend_active_load_latch_v2.ext - technology: sky130A

.subckt sky130_isolated_frontend_active_load_latch_v2 out_p out_n latch_sense_p latch_sense_n
+ tail reset vdd vss eval sense_p sense_n iso_tail vdd_active
X0 latch_sense_p sense_p iso_tail vss sky130_fd_pr__nfet_01v8 ad=3.36 pd=8 as=3.12 ps=7.6 w=1.2 l=0.6
X1 out_p out_n tail vss sky130_fd_pr__nfet_01v8 ad=3.36 pd=8 as=3.12 ps=7.6 w=1.2 l=0.6
X2 out_n latch_sense_n tail vss sky130_fd_pr__nfet_01v8 ad=3.36 pd=8 as=3.12 ps=7.6 w=1.2 l=0.6
X3 out_n out_p vdd_active vdd_active sky130_fd_pr__pfet_01v8 ad=3.36 pd=8 as=3.12 ps=7.6 w=1.2 l=0.6
X4 iso_tail sense_n latch_sense_n vss sky130_fd_pr__nfet_01v8 ad=3.12 pd=7.6 as=3.36 ps=8 w=1.2 l=0.6
X5 out_n out_p tail vss sky130_fd_pr__nfet_01v8 ad=3.36 pd=8 as=3.12 ps=7.6 w=1.2 l=0.6
X6 out_n reset vdd vdd sky130_fd_pr__pfet_01v8 ad=3.36 pd=8 as=3.12 ps=7.6 w=1.2 l=0.6
X7 out_p latch_sense_p tail vss sky130_fd_pr__nfet_01v8 ad=3.36 pd=8 as=3.12 ps=7.6 w=1.2 l=0.6
X8 tail eval vss vss sky130_fd_pr__nfet_01v8 ad=16.8 pd=17.6 as=15.6 ps=17.2 w=6 l=0.6
X9 out_p out_n vdd_active vdd_active sky130_fd_pr__pfet_01v8 ad=3.36 pd=8 as=3.12 ps=7.6 w=1.2 l=0.6
X10 out_p reset vdd vdd sky130_fd_pr__pfet_01v8 ad=3.36 pd=8 as=3.12 ps=7.6 w=1.2 l=0.6
C0 out_p latch_sense_p 0.32159f
C1 out_p out_n 1.85382f
C2 tail latch_sense_n 0.4349f
C3 out_p vdd_active 4.31746f
C4 reset out_n 0.05967f
C5 sense_p latch_sense_p 0.06485f
C6 eval out_n 0.02298f
C7 sense_n latch_sense_n 0.05507f
C8 out_p latch_sense_n 1.00043f
C9 tail out_p 3.33055f
C10 iso_tail latch_sense_p 0.09804f
C11 latch_sense_n m1_3440_12500# 0.0106f
C12 tail eval 0.09415f
C13 out_n vdd 0.95698f
C14 iso_tail latch_sense_n 0.15122f
C15 reset out_p 0.07615f
C16 sense_p m1_1000_12500# 0.04904f
C17 out_n latch_sense_p 0.27084f
C18 eval out_p 0.04062f
C19 vdd_active latch_sense_p 0.50449f
C20 out_n vdd_active 5.52673f
C21 sense_n m1_3440_12500# 0.04904f
C22 iso_tail m1_1000_12500# 0.00302f
C23 sense_n iso_tail 0.11179f
C24 latch_sense_n latch_sense_p 0.0207f
C25 out_n latch_sense_n 1.04924f
C26 vdd_active latch_sense_n 0.53393f
C27 tail latch_sense_p 0.36163f
C28 tail out_n 2.28538f
C29 sense_p iso_tail 0.12292f
C30 out_p vdd 1.0487f
C31 iso_tail m1_3440_12500# 0.00302f
C32 latch_sense_p m1_1000_12500# 0.05106f
C33 reset vdd 4.28849f
C34 reset vss 0.8786f
C35 tail vss 10.0187f
C36 eval vss 1.1758f
C37 out_p vss 15.1647f
C38 out_n vss 16.2693f
C39 latch_sense_n vss 9.45522f
C40 latch_sense_p vss 6.9417f
C41 iso_tail vss 2.81735f
C42 sense_n vss 1.42522f
C43 sense_p vss 1.42522f
C44 vdd vss 30.6807f
C45 vdd_active vss 45.577f
C46 m1_3440_12500# vss 0.33861f
C47 m1_1000_12500# vss 0.33861f
.ends
