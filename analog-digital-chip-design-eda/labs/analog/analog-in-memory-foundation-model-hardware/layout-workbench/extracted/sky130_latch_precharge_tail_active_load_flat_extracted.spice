* NGSPICE file created from sky130_latch_precharge_tail_active_load_flat.ext - technology: sky130A

.subckt sky130_latch_precharge_tail_active_load_flat out_p out_n sense_p sense_n tail
+ reset vdd vss eval
X0 out_p out_n tail VSUBS sky130_fd_pr__nfet_01v8 ad=3.36 pd=8 as=3.12 ps=7.6 w=1.2 l=0.6
X1 out_n sense_n tail VSUBS sky130_fd_pr__nfet_01v8 ad=3.36 pd=8 as=3.12 ps=7.6 w=1.2 l=0.6
X2 out_n out_p vdd_active vdd_active sky130_fd_pr__pfet_01v8 ad=3.36 pd=8 as=3.12 ps=7.6 w=1.2 l=0.6
X3 out_n out_p tail VSUBS sky130_fd_pr__nfet_01v8 ad=3.36 pd=8 as=3.12 ps=7.6 w=1.2 l=0.6
X4 out_n reset vdd w_12400_300# sky130_fd_pr__pfet_01v8 ad=3.36 pd=8 as=3.12 ps=7.6 w=1.2 l=0.6
X5 out_p sense_p tail VSUBS sky130_fd_pr__nfet_01v8 ad=3.36 pd=8 as=3.12 ps=7.6 w=1.2 l=0.6
X6 tail eval vss VSUBS sky130_fd_pr__nfet_01v8 ad=16.8 pd=17.6 as=15.6 ps=17.2 w=6 l=0.6
X7 out_p out_n vdd_active vdd_active sky130_fd_pr__pfet_01v8 ad=3.36 pd=8 as=3.12 ps=7.6 w=1.2 l=0.6
X8 out_p reset vdd w_12400_300# sky130_fd_pr__pfet_01v8 ad=3.36 pd=8 as=3.12 ps=7.6 w=1.2 l=0.6
C0 tail out_p 3.33055f
C1 vdd out_p 0.28588f
C2 tail eval 0.09415f
C3 reset vdd 0.20878f
C4 vss out_p 0.1661f
C5 vdd w_12400_300# 1.53672f
C6 sense_n out_n 0.04664f
C7 vss eval 0.04634f
C8 tail vss 0.19272f
C9 out_p out_n 1.91368f
C10 sense_n out_p 0.00703f
C11 vdd_active out_n 5.52673f
C12 reset out_n 0.05967f
C13 out_n w_12400_300# 0.70572f
C14 eval out_n 0.02298f
C15 sense_p out_p 0.04035f
C16 tail out_n 2.28538f
C17 tail sense_n 0.1962f
C18 vdd_active out_p 4.31746f
C19 reset out_p 0.07615f
C20 vdd out_n 0.07263f
C21 out_p w_12400_300# 0.76428f
C22 eval out_p 0.04062f
C23 sense_p tail 0.18959f
C24 vss out_n 0.06009f
C25 reset w_12400_300# 4.03573f
C26 vdd VSUBS 0.90789f
C27 tail VSUBS 20.46342f
C28 vss VSUBS 0.75002f
C29 out_p VSUBS 7.58271f
C30 w_12400_300# VSUBS 30f
C31 vdd_active VSUBS 63.96194f
.ends
