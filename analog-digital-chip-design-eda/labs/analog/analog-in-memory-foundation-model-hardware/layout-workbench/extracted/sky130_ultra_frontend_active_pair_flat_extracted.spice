* NGSPICE file created from sky130_ultra_frontend_active_pair_flat.ext - technology: sky130A

.subckt sky130_ultra_frontend_active_pair_flat vss vdd sample_p sense_p clk_sample
+ vcm_reset clk_latch sense_n sample_n iso_tail_flat iso_p_flat iso_n_flat
X0 iso_tail_flat sense_n iso_n_flat VSUBS sky130_fd_pr__nfet_01v8 ad=3.12 pd=7.6 as=3.36 ps=8 w=1.2 l=0.6
X1 iso_p_flat sense_p iso_tail_flat VSUBS sky130_fd_pr__nfet_01v8 ad=3.36 pd=8 as=3.12 ps=7.6 w=1.2 l=0.6
C0 sense_n m2_8900_1800# 0.04564f
C1 clk_sample vss 0.23373f
C2 sense_n sample_n 0.80429f
C3 vcm_reset vss 0.23025f
C4 symmetric_reset_region ultra_sample_n_sense_n_region 0.00907f
C5 sense_p ultra_sample_p_sense_p_region 1.79971f
C6 vdd clk_latch 0.22562f
C7 ultra_sample_n_sense_n_region clk_latch 0.01482f
C8 m1_11440_900# iso_tail_flat 0.0015f
C9 iso_p_flat iso_n_flat 0.00782f
C10 clk_sample symmetric_latch_clock_region 0.37954f
C11 m2_8900_1800# m1_11440_900# 0.01113f
C12 vcm_reset symmetric_latch_clock_region 0.46074f
C13 sample_p vss 0.18668f
C14 vss ultra_sample_n_sense_n_region 0.05867f
C15 sense_p iso_tail_flat 0.15361f
C16 vcm_reset clk_sample 0.125f
C17 sense_p m2_8900_1800# 0.05059f
C18 sense_n vss 0.19187f
C19 ultra_sample_p_sense_p_region symmetric_reset_region 0.00907f
C20 m2_8900_1800# iso_tail_flat 0.34398f
C21 sense_p sample_n 0.19026f
C22 ultra_sample_n_sense_n_region symmetric_latch_clock_region 0.00907f
C23 vdd clk_sample 0.22562f
C24 sense_p symmetric_reset_region 0.08585f
C25 vdd vcm_reset 0.22214f
C26 sense_p clk_latch 0.20937f
C27 ultra_sample_p_sense_p_region vss 0.05867f
C28 sense_p iso_p_flat 0.02157f
C29 sense_p vss 0.19187f
C30 vdd sample_p 0.18668f
C31 iso_p_flat iso_tail_flat 0.05749f
C32 sense_n iso_n_flat 0.02157f
C33 ultra_sample_p_sense_p_region symmetric_latch_clock_region 0.00907f
C34 m2_8900_1800# iso_p_flat 0.41846f
C35 sense_n vdd 0.20824f
C36 clk_sample ultra_sample_p_sense_p_region 0.01482f
C37 sense_n ultra_sample_n_sense_n_region 1.68641f
C38 symmetric_reset_region clk_latch 0.37792f
C39 vss sample_n 0.18668f
C40 sense_p m1_9000_900# 0.04555f
C41 m1_9000_900# iso_tail_flat 0.0015f
C42 sense_p clk_sample 0.20937f
C43 sense_p vcm_reset 0.20659f
C44 m1_11440_900# iso_n_flat 0.0015f
C45 m2_8900_1800# m1_9000_900# 0.01113f
C46 vdd ultra_sample_p_sense_p_region 0.01564f
C47 vss clk_latch 0.23373f
C48 sample_p ultra_sample_p_sense_p_region 1.54805f
C49 iso_n_flat iso_tail_flat 0.05717f
C50 sense_p vdd 1.03026f
C51 symmetric_reset_region symmetric_latch_clock_region 0.04571f
C52 sense_n m1_11440_900# 0.04555f
C53 sense_p sample_p 0.81576f
C54 sense_p ultra_sample_n_sense_n_region 0.15529f
C55 m2_8900_1800# iso_n_flat 0.41846f
C56 clk_sample symmetric_reset_region 0.37792f
C57 symmetric_latch_clock_region clk_latch 0.37954f
C58 vcm_reset symmetric_reset_region 0.45911f
C59 sense_n sense_p 0.42691f
C60 vcm_reset clk_latch 0.125f
C61 sense_n iso_tail_flat 0.14768f
C62 vdd sample_n 0.17983f
C63 ultra_sample_n_sense_n_region sample_n 1.5412f
C64 m1_9000_900# iso_p_flat 0.0015f
C65 vss symmetric_latch_clock_region 0.05101f
C66 sample_n VSUBS 0.51538f
C67 clk_latch VSUBS 0.78545f
C68 vcm_reset VSUBS 0.49259f
C69 clk_sample VSUBS 0.78545f
C70 sample_p VSUBS 0.60102f
C71 vss VSUBS 3.15132f
C72 vdd VSUBS 2.51894f
C73 iso_n_flat VSUBS 3.09478f
C74 iso_p_flat VSUBS 3.01951f
C75 iso_tail_flat VSUBS 8.21783f
C76 m2_8900_1800# VSUBS 0.99613f ; **FLOATING
C77 m1_11440_900# VSUBS 0.31893f ; **FLOATING
C78 m1_9000_900# VSUBS 0.31893f ; **FLOATING
C79 ultra_sample_n_sense_n_region VSUBS 2.48755f ; **FLOATING
C80 symmetric_latch_clock_region VSUBS 0.96795f ; **FLOATING
C81 symmetric_reset_region VSUBS 0.91055f ; **FLOATING
C82 ultra_sample_p_sense_p_region VSUBS 2.50824f ; **FLOATING
.ends
