* NGSPICE file created from sky130_active_isolation_pair_wrapper.ext - technology: sky130A

.subckt sky130_transistor_active_isolation_pair iso_tail iso_p iso_n sense_p sense_n
+ VSUBS
X0 iso_tail sense_n iso_n VSUBS sky130_fd_pr__nfet_01v8 ad=3.12 pd=7.6 as=3.36 ps=8 w=1.2 l=0.6
X1 iso_p sense_p iso_tail VSUBS sky130_fd_pr__nfet_01v8 ad=3.36 pd=8 as=3.12 ps=7.6 w=1.2 l=0.6
C0 iso_p iso_tail 0.05749f
C1 iso_n iso_p 0.00782f
C2 m1_1000_500# iso_p 0.0015f
C3 m2_900_1400# sense_n 0.04273f
C4 sense_p iso_tail 0.12292f
C5 m2_900_1400# m1_3440_500# 0.01113f
C6 m1_1000_500# sense_p 0.04555f
C7 m2_900_1400# iso_tail 0.34398f
C8 m2_900_1400# iso_n 0.41846f
C9 m1_3440_500# sense_n 0.04555f
C10 m2_900_1400# m1_1000_500# 0.01113f
C11 sense_p iso_p 0.02157f
C12 sense_n iso_tail 0.11179f
C13 iso_n sense_n 0.02157f
C14 m2_900_1400# iso_p 0.41846f
C15 m1_3440_500# iso_tail 0.0015f
C16 iso_n m1_3440_500# 0.0015f
C17 m2_900_1400# sense_p 0.04273f
C18 iso_n iso_tail 0.05717f
C19 m1_1000_500# iso_tail 0.0015f
C20 iso_n VSUBS 1.04634f
C21 iso_p VSUBS 1.04634f
C22 iso_tail VSUBS 4.24257f
C23 m2_900_1400# VSUBS 1.01648f ; **FLOATING
C24 m1_3440_500# VSUBS 0.31893f ; **FLOATING
C25 m1_1000_500# VSUBS 0.31893f ; **FLOATING
.ends

.subckt sky130_active_isolation_pair_wrapper
Xsky130_transistor_active_isolation_pair_0 sky130_transistor_active_isolation_pair_0/iso_tail
+ sky130_transistor_active_isolation_pair_0/iso_p sky130_transistor_active_isolation_pair_0/iso_n
+ sky130_transistor_active_isolation_pair_0/sense_p sky130_transistor_active_isolation_pair_0/sense_n
+ VSUBS sky130_transistor_active_isolation_pair
.ends
