* NGSPICE file created from sky130_pmos_precharge_pair_starter.ext - technology: sky130A

.subckt sky130_pmos_precharge_pair_starter vdd precharge_p precharge_n reset vdd_uq0
+ reset_uq0
X0 precharge_n reset_uq0 vdd_uq0 w_400_300# sky130_fd_pr__pfet_01v8 ad=3.36 pd=8 as=3.12 ps=7.6 w=1.2 l=0.6
X1 precharge_p reset vdd w_400_300# sky130_fd_pr__pfet_01v8 ad=3.36 pd=8 as=3.12 ps=7.6 w=1.2 l=0.6
C0 precharge_p vdd 0.03982f
C1 w_400_300# precharge_n 0.3244f
C2 reset_uq0 precharge_n 0.02459f
C3 vdd reset 0.02892f
C4 precharge_p vdd_uq0 0.01164f
C5 vdd w_400_300# 0.32404f
C6 precharge_p reset 0.02459f
C7 precharge_p w_400_300# 0.34291f
C8 reset vdd_uq0 0
C9 precharge_p reset_uq0 0
C10 w_400_300# vdd_uq0 0.34255f
C11 reset_uq0 vdd_uq0 0.02892f
C12 reset w_400_300# 1.82041f
C13 reset_uq0 w_400_300# 1.82238f
C14 precharge_n vdd_uq0 0.03982f
C15 precharge_n VSUBS 0.2029f
C16 vdd_uq0 VSUBS 0.15756f
C17 precharge_p VSUBS 0.15855f
C18 vdd VSUBS 0.20389f
C19 w_400_300# VSUBS 30f
.ends
