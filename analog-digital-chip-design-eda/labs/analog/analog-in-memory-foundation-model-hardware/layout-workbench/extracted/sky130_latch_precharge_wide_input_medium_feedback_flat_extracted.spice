* NGSPICE file created from sky130_latch_precharge_wide_input_medium_feedback_flat.ext - technology: sky130A

.subckt sky130_latch_precharge_wide_input_medium_feedback_flat out_p out_n sense_p
+ sense_n tail reset vdd
X0 out_n out_p tail VSUBS sky130_fd_pr__nfet_01v8 ad=3.24 pd=7.8 as=3 ps=7.4 w=1.2 l=0.8
X1 out_p sense_p tail VSUBS sky130_fd_pr__nfet_01v8 ad=16.8 pd=17.6 as=15.6 ps=17.2 w=6 l=0.6
X2 out_n sense_n tail VSUBS sky130_fd_pr__nfet_01v8 ad=16.8 pd=17.6 as=15.6 ps=17.2 w=6 l=0.6
X3 out_n reset vdd w_12400_300# sky130_fd_pr__pfet_01v8 ad=3.36 pd=8 as=3.12 ps=7.6 w=1.2 l=0.6
X4 out_p out_n tail VSUBS sky130_fd_pr__nfet_01v8 ad=3.24 pd=7.8 as=3 ps=7.4 w=1.2 l=0.8
X5 out_p reset vdd w_12400_300# sky130_fd_pr__pfet_01v8 ad=3.36 pd=8 as=3.12 ps=7.6 w=1.2 l=0.6
C0 out_p sense_p 0.05301f
C1 tail out_n 2.03185f
C2 reset out_n 0.05967f
C3 out_p out_n 1.42023f
C4 out_n sense_n 0.06074f
C5 vdd out_n 0.07263f
C6 w_12400_300# out_n 0.70572f
C7 out_p tail 2.14101f
C8 out_p reset 0.07615f
C9 tail sense_n 0.19827f
C10 vdd reset 0.20878f
C11 out_p sense_n 0.00703f
C12 vdd out_p 0.28588f
C13 w_12400_300# reset 4.03573f
C14 out_p w_12400_300# 0.76428f
C15 sense_p tail 0.19338f
C16 vdd w_12400_300# 1.53672f
C17 vdd VSUBS 0.90789f
C18 out_p VSUBS 11.74542f
C19 tail VSUBS 25.78658f
C20 w_12400_300# VSUBS 30f
.ends
