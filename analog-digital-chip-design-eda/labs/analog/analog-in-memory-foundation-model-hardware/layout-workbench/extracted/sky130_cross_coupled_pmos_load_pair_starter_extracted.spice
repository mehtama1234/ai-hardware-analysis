* NGSPICE file created from sky130_cross_coupled_pmos_load_pair_starter.ext - technology: sky130A

.subckt sky130_cross_coupled_pmos_load_pair_starter vdd out_p out_n
X0 out_n out_p vdd vdd sky130_fd_pr__pfet_01v8 ad=3.36 pd=8 as=3.12 ps=7.6 w=1.2 l=0.6
X1 out_p out_n vdd vdd sky130_fd_pr__pfet_01v8 ad=3.36 pd=8 as=3.12 ps=7.6 w=1.2 l=0.6
C0 vdd out_p 3.43835f
C1 out_n out_p 0.31877f
C2 vdd out_n 4.27897f
C3 out_p VSUBS 0.57743f
C4 vdd VSUBS 31.19562f
.ends
