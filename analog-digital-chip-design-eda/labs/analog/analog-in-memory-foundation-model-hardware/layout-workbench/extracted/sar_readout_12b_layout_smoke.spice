* NGSPICE file created from sar_readout_12b.ext - technology: sky130A

.subckt sar_readout_12b vss sample_in vdd
C0 sample_in vss 1.05402f
C1 sample_in vdd 1.3202f
C2 vdd vss 0.53484f
C3 vss VSUBS 1.38755f
C4 sample_in VSUBS 1.67154f
C5 vdd VSUBS 1.7846f
.ends
