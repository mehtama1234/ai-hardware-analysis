* NGSPICE file created from sky130_clocked_tail_switch_starter.ext - technology: sky130A

.subckt sky130_clocked_tail_switch_starter vss tail eval
X0 tail eval vss VSUBS sky130_fd_pr__nfet_01v8 ad=16.8 pd=17.6 as=15.6 ps=17.2 w=6 l=0.6
C0 eval tail 0.04278f
C1 vss tail 0.04805f
C2 eval vss 0.04634f
C3 tail VSUBS 0.75002f
C4 vss VSUBS 0.75002f
.ends
