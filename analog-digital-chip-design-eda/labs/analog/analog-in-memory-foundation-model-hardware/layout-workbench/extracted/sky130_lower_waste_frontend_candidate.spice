* NGSPICE file created from sky130_ultra_sense_capacitive_frontend.ext - technology: sky130A

.subckt sky130_lower_waste_frontend_candidate vss vdd sample_p sense_p clk_sample
+ vcm_reset clk_latch sense_n sample_n
C0 vss clk_latch 0.23373f
C1 clk_sample symmetric_reset_region 0.37954f
C2 symmetric_reset_region ultra_sample_p_sense_p_region 0.00907f
C3 ultra_sample_n_sense_n_region symmetric_reset_region 0.00907f
C4 sense_p ultra_sample_p_sense_p_region 0.81758607f
C5 clk_latch vcm_reset 0.125f
C6 sample_n ultra_sample_n_sense_n_region 1.54805f
C7 vdd clk_latch 0.23373f
C8 vss sense_p 0.092675662f
C9 sample_p ultra_sample_p_sense_p_region 1.54805f
C10 sample_n vss 0.18668f
C11 clk_sample symmetric_latch_clock_region 0.37954f
C12 vcm_reset symmetric_reset_region 0.46074f
C13 symmetric_latch_clock_region ultra_sample_p_sense_p_region 0.00907f
C14 ultra_sample_n_sense_n_region symmetric_latch_clock_region 0.00907f
C15 sample_n sense_n 0.8f
C16 sample_p vss 0.18668f
C17 vdd symmetric_reset_region 0.05101f
C18 clk_sample ultra_sample_p_sense_p_region 0.01482f
C19 vdd sense_p 0.092675662f
C20 sample_n vdd 0.18668f
C21 vss symmetric_latch_clock_region 0.05101f
C22 clk_latch symmetric_reset_region 0.37954f
C23 vss clk_sample 0.23373f
C24 sample_p vdd 0.18668f
C25 vcm_reset symmetric_latch_clock_region 0.46074f
C26 vss ultra_sample_p_sense_p_region 0.05867f
C27 vss ultra_sample_n_sense_n_region 0.05867f
C28 clk_sample vcm_reset 0.125f
C29 sense_n ultra_sample_n_sense_n_region 0.81758607f
C30 vdd clk_sample 0.23373f
C31 vdd ultra_sample_p_sense_p_region 0.05867f
C32 vdd ultra_sample_n_sense_n_region 0.05867f
C33 clk_latch symmetric_latch_clock_region 0.37954f
C34 vss vcm_reset 0.23025f
C35 sense_n vss 0.092675662f
C36 ultra_sample_n_sense_n_region clk_latch 0.01482f
C37 sample_p sense_p 0.8f
C38 symmetric_latch_clock_region symmetric_reset_region 0.04571f
C39 vdd vcm_reset 0.23025f
C40 sense_n vdd 0.092675662f
C41 sample_n VSUBS 0.60102f
C42 sense_n VSUBS 0.20119897f
C43 clk_latch VSUBS 0.8327f
C44 vcm_reset VSUBS 0.53148f
C45 clk_sample VSUBS 0.8327f
C46 sense_p VSUBS 0.20119897f
C47 sample_p VSUBS 0.60102f
C48 vss VSUBS 3.15132f
C49 vdd VSUBS 3.15132f
C50 ultra_sample_n_sense_n_region VSUBS 2.56515f ; **FLOATING
C51 symmetric_latch_clock_region VSUBS 0.96795f ; **FLOATING
C52 symmetric_reset_region VSUBS 0.96795f ; **FLOATING
C53 ultra_sample_p_sense_p_region VSUBS 2.56515f ; **FLOATING
.ends sky130_lower_waste_frontend_candidate
