* NGSPICE file created from row_dac_10b.ext - technology: sky130A

.subckt row_dac_10b vss row_drive vdd
C0 row_drive vdd 1.08417f
C1 vdd vss 0.78467f
C2 row_drive vss 1.07709f
C3 vss VSUBS 1.40333f
C4 row_drive VSUBS 0.95642f
C5 vdd VSUBS 1.38963f
.ends
