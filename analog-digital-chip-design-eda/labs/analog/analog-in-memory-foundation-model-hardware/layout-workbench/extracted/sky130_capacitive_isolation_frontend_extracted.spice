* NGSPICE file created from sky130_capacitive_isolation_frontend.ext - technology: sky130A

.subckt sky130_capacitive_isolation_frontend vss vdd sample_p latch_gate_p clk latch_gate_n
+ sample_n
C0 latch_gate_p clk 0.09639f
C1 latch_gate_p vdd 0.24969f
C2 latch_gate_n latch_gate_p 0.00602f
C3 clk vdd 0.25856f
C4 latch_gate_n clk 0.08219f
C5 latch_gate_n vdd 0.25082f
C6 sample_p vss 0.22515f
C7 vss sample_n 0.22515f
C8 vss latch_gate_p 0.28005f
C9 vss clk 0.24348f
C10 sample_p latch_gate_p 0.31916f
C11 latch_gate_n vss 0.28118f
C12 sample_p clk 0
C13 sample_p vdd 0.22701f
C14 clk sample_n 0
C15 vdd sample_n 0.22701f
C16 latch_gate_n sample_n 0.31916f
C17 sample_n VSUBS 0.59575f
C18 sample_p VSUBS 0.59575f
C19 vss VSUBS 1.7766f
C20 latch_gate_n VSUBS 0.89368f
C21 latch_gate_p VSUBS 0.87773f
C22 clk VSUBS 0.76681f
C23 vdd VSUBS 1.85892f
.ends
