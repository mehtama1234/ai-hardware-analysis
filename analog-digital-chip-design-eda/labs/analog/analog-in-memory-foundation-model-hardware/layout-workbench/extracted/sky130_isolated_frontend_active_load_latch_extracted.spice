* NGSPICE file created from sky130_isolated_frontend_active_load_latch.ext - technology: sky130A

.subckt sky130_isolated_frontend_active_load_latch latch_sense_n tail reset vdd vss
+ eval sense_p sense_n iso_tail
X0 tail sense_p iso_tail VSUBS sky130_fd_pr__nfet_01v8 ad=3.36 pd=8 as=3.12 ps=7.6 w=1.2 l=0.6
X1 tail tail tail VSUBS sky130_fd_pr__nfet_01v8 ad=3.12 pd=7.6 as=49.44 ps=96 w=1.2 l=0.6
X2 tail latch_sense_n tail VSUBS sky130_fd_pr__nfet_01v8 ad=3.12 pd=7.6 as=0 ps=0 w=1.2 l=0.6
X3 tail tail vdd_active vdd_active sky130_fd_pr__pfet_01v8 ad=3.36 pd=8 as=3.12 ps=7.6 w=1.2 l=0.6
X4 iso_tail sense_n tail VSUBS sky130_fd_pr__nfet_01v8 ad=3.12 pd=7.6 as=3.36 ps=8 w=1.2 l=0.6
X5 tail tail tail VSUBS sky130_fd_pr__nfet_01v8 ad=3.12 pd=7.6 as=0 ps=0 w=1.2 l=0.6
X6 tail reset vdd w_12400_300# sky130_fd_pr__pfet_01v8 ad=3.36 pd=8 as=3.12 ps=7.6 w=1.2 l=0.6
X7 tail tail tail VSUBS sky130_fd_pr__nfet_01v8 ad=3.12 pd=7.6 as=0 ps=0 w=1.2 l=0.6
X8 tail eval vss VSUBS sky130_fd_pr__nfet_01v8 ad=16.8 pd=17.6 as=15.6 ps=17.2 w=6 l=0.6
X9 tail tail vdd_active vdd_active sky130_fd_pr__pfet_01v8 ad=3.36 pd=8 as=3.12 ps=7.6 w=1.2 l=0.6
X10 tail reset vdd w_12400_300# sky130_fd_pr__pfet_01v8 ad=3.36 pd=8 as=3.12 ps=7.6 w=1.2 l=0.6
C0 tail vss 0.41891f
C1 sense_n iso_tail 0.11179f
C2 vdd reset 0.20878f
C3 reset w_12400_300# 4.03573f
C4 tail vdd_active 10.4692f
C5 iso_tail tail 0.64106f
C6 reset tail 0.13583f
C7 m1_1000_12500# iso_tail 0.0015f
C8 vss eval 0.04634f
C9 vdd w_12400_300# 1.53672f
C10 sense_n tail 0.10073f
C11 vdd tail 0.35851f
C12 sense_p iso_tail 0.12292f
C13 tail w_12400_300# 1.47001f
C14 m1_3440_12500# iso_tail 0.0015f
C15 m1_1000_12500# tail 0.1519f
C16 sense_p tail 0.12342f
C17 sense_n m1_3440_12500# 0.04555f
C18 sense_p m1_1000_12500# 0.04555f
C19 tail eval 0.15775f
C20 latch_sense_n tail 0.24987f
C21 m1_3440_12500# tail 0.01651f
C22 vdd VSUBS 0.90789f
C23 vss VSUBS 0.75002f
C24 iso_tail VSUBS 4.24257f
C25 m1_3440_12500# VSUBS 0.31893f ; **FLOATING
C26 m1_1000_12500# VSUBS 0.31893f ; **FLOATING
C27 w_12400_300# VSUBS 30f
C28 vdd_active VSUBS 46.8334f
.ends
