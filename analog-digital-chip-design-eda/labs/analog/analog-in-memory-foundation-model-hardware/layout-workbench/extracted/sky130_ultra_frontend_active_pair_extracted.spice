* NGSPICE file created from sky130_ultra_frontend_active_pair.ext - technology: sky130A

.subckt sky130_transistor_active_isolation_pair iso_tail iso_p iso_n sense_p sense_n
+ m1_1000_500# m2_900_1400# VSUBS
X0 iso_tail sense_n iso_n VSUBS sky130_fd_pr__nfet_01v8 ad=3.12 pd=7.6 as=3.36 ps=8 w=1.2 l=0.6
X1 iso_p sense_p iso_tail VSUBS sky130_fd_pr__nfet_01v8 ad=3.36 pd=8 as=3.12 ps=7.6 w=1.2 l=0.6
C0 m1_1000_500# iso_p 0.0015f
C1 iso_tail iso_n 0.05717f
C2 sense_n iso_n 0.02157f
C3 m1_3440_500# m2_900_1400# 0.01113f
C4 m2_900_1400# iso_p 0.41846f
C5 iso_tail sense_p 0.12292f
C6 iso_tail sense_n 0.11179f
C7 m1_1000_500# sense_p 0.04555f
C8 m2_900_1400# iso_n 0.41846f
C9 iso_tail m1_1000_500# 0.0015f
C10 m1_3440_500# iso_n 0.0015f
C11 m2_900_1400# sense_p 0.04273f
C12 iso_p iso_n 0.00782f
C13 iso_tail m2_900_1400# 0.34398f
C14 m2_900_1400# sense_n 0.04273f
C15 m1_1000_500# m2_900_1400# 0.01113f
C16 m1_3440_500# iso_tail 0.0015f
C17 sense_p iso_p 0.02157f
C18 m1_3440_500# sense_n 0.04555f
C19 iso_tail iso_p 0.05749f
C20 iso_n VSUBS 1.04634f
C21 iso_p VSUBS 1.04634f
C22 iso_tail VSUBS 4.24257f
C23 m2_900_1400# VSUBS 1.01648f
C24 m1_3440_500# VSUBS 0.31893f ; **FLOATING
C25 m1_1000_500# VSUBS 0.31893f
.ends

.subckt sky130_ultra_frontend_active_pair
Xsky130_transistor_active_isolation_pair_0 sky130_transistor_active_isolation_pair_0/iso_tail
+ sky130_transistor_active_isolation_pair_0/iso_p sky130_transistor_active_isolation_pair_0/iso_n
+ sky130_transistor_active_isolation_pair_0/sense_p sky130_transistor_active_isolation_pair_0/sense_n
+ sky130_transistor_active_isolation_pair_0/m1_1000_500# sky130_transistor_active_isolation_pair_0/m2_900_1400#
+ VSUBS sky130_transistor_active_isolation_pair
C0 sky130_transistor_active_isolation_pair_0/sense_p sky130_ultra_sense_capacitive_frontend_0/sense_p 0.11435f
C1 sky130_transistor_active_isolation_pair_0/m2_900_1400# sky130_transistor_active_isolation_pair_0/sense_n 0.00291f
C2 sky130_ultra_sense_capacitive_frontend_0/ultra_sample_n_sense_n_region sky130_ultra_sense_capacitive_frontend_0/sense_p 4.28448f
C3 sky130_transistor_active_isolation_pair_0/sense_n sky130_ultra_sense_capacitive_frontend_0/sense_p 0.12357f
C4 sky130_ultra_sense_capacitive_frontend_0/vss sky130_ultra_sense_capacitive_frontend_0/sample_p 0.18668f
C5 sky130_ultra_sense_capacitive_frontend_0/ultra_sample_p_sense_p_region sky130_ultra_sense_capacitive_frontend_0/sense_p 2.58355f
C6 sky130_ultra_sense_capacitive_frontend_0/vdd sky130_ultra_sense_capacitive_frontend_0/sense_p 1.32075f
C7 sky130_transistor_active_isolation_pair_0/m1_1000_500# sky130_transistor_active_isolation_pair_0/iso_tail -0
C8 sky130_ultra_sense_capacitive_frontend_0/vss sky130_ultra_sense_capacitive_frontend_0/symmetric_latch_clock_region 0.05101f
C9 sky130_ultra_sense_capacitive_frontend_0/ultra_sample_n_sense_n_region sky130_ultra_sense_capacitive_frontend_0/vdd 0.05867f
C10 sky130_ultra_sense_capacitive_frontend_0/vdd sky130_ultra_sense_capacitive_frontend_0/ultra_sample_p_sense_p_region 0.05867f
C11 sky130_ultra_sense_capacitive_frontend_0/symmetric_latch_clock_region sky130_ultra_sense_capacitive_frontend_0/symmetric_reset_region 0.04571f
C12 sky130_ultra_sense_capacitive_frontend_0/vss sky130_ultra_sense_capacitive_frontend_0/sense_p 1.27816f
C13 sky130_transistor_active_isolation_pair_0/iso_tail sky130_transistor_active_isolation_pair_0/m2_900_1400# -0.00256f
C14 sky130_transistor_active_isolation_pair_0/iso_tail sky130_transistor_active_isolation_pair_0/iso_p -0.00196f
C15 sky130_transistor_active_isolation_pair_0/iso_tail sky130_ultra_sense_capacitive_frontend_0/sense_p 0.27215f
C16 sky130_transistor_active_isolation_pair_0/iso_tail sky130_transistor_active_isolation_pair_0/sense_p -0
C17 sky130_transistor_active_isolation_pair_0/m1_1000_500# sky130_transistor_active_isolation_pair_0/m2_900_1400# -0.00654f
C18 sky130_ultra_sense_capacitive_frontend_0/sample_p sky130_ultra_sense_capacitive_frontend_0/sense_p 0.8f
C19 sky130_ultra_sense_capacitive_frontend_0/vss sky130_ultra_sense_capacitive_frontend_0/ultra_sample_n_sense_n_region 0.05867f
C20 sky130_transistor_active_isolation_pair_0/m1_1000_500# sky130_ultra_sense_capacitive_frontend_0/sense_p 0.01328f
C21 sky130_transistor_active_isolation_pair_0/m1_1000_500# sky130_transistor_active_isolation_pair_0/sense_p -0.00511f
C22 sky130_transistor_active_isolation_pair_0/iso_n sky130_ultra_sense_capacitive_frontend_0/sense_p 0
C23 sky130_ultra_sense_capacitive_frontend_0/vss sky130_ultra_sense_capacitive_frontend_0/ultra_sample_p_sense_p_region 0.05867f
C24 sky130_ultra_sense_capacitive_frontend_0/symmetric_reset_region sky130_ultra_sense_capacitive_frontend_0/sense_p 1.27747f
C25 sky130_transistor_active_isolation_pair_0/iso_tail sky130_transistor_active_isolation_pair_0/sense_n 0
C26 sky130_ultra_sense_capacitive_frontend_0/symmetric_latch_clock_region sky130_ultra_sense_capacitive_frontend_0/sense_p 1.27747f
C27 sky130_ultra_sense_capacitive_frontend_0/sample_p sky130_ultra_sense_capacitive_frontend_0/ultra_sample_p_sense_p_region 1.54805f
C28 sky130_ultra_sense_capacitive_frontend_0/vdd sky130_ultra_sense_capacitive_frontend_0/sample_p 0.18668f
C29 sky130_ultra_sense_capacitive_frontend_0/ultra_sample_n_sense_n_region sky130_ultra_sense_capacitive_frontend_0/symmetric_reset_region 0.00907f
C30 sky130_ultra_sense_capacitive_frontend_0/ultra_sample_n_sense_n_region sky130_ultra_sense_capacitive_frontend_0/symmetric_latch_clock_region 0.00907f
C31 sky130_transistor_active_isolation_pair_0/m2_900_1400# sky130_ultra_sense_capacitive_frontend_0/sense_p 0.04757f
C32 sky130_transistor_active_isolation_pair_0/m2_900_1400# sky130_transistor_active_isolation_pair_0/sense_p -0.00895f
C33 sky130_ultra_sense_capacitive_frontend_0/sense_p sky130_transistor_active_isolation_pair_0/iso_p 0.00686f
C34 sky130_ultra_sense_capacitive_frontend_0/vdd sky130_ultra_sense_capacitive_frontend_0/symmetric_reset_region 0.05101f
C35 sky130_ultra_sense_capacitive_frontend_0/ultra_sample_p_sense_p_region sky130_ultra_sense_capacitive_frontend_0/symmetric_reset_region 0.00907f
C36 sky130_transistor_active_isolation_pair_0/sense_p sky130_transistor_active_isolation_pair_0/iso_p 0
C37 sky130_ultra_sense_capacitive_frontend_0/symmetric_latch_clock_region sky130_ultra_sense_capacitive_frontend_0/ultra_sample_p_sense_p_region 0.00907f
C38 sky130_ultra_sense_capacitive_frontend_0/sense_p VSUBS 4.81226f
C39 sky130_transistor_active_isolation_pair_0/sense_n VSUBS 0.82554f
C40 sky130_transistor_active_isolation_pair_0/sense_p VSUBS 0.06948f
.ends
