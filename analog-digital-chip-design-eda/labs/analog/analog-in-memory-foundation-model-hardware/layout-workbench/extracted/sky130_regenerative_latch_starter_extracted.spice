* NGSPICE file created from sky130_regenerative_latch_starter.ext - technology: sky130A

.subckt sky130_regenerative_latch_starter out_p out_n sense_p sense_n tail
X0 out_p out_n tail VSUBS sky130_fd_pr__nfet_01v8 ad=3.36 pd=8 as=3.12 ps=7.6 w=1.2 l=0.6
X1 out_n sense_n tail VSUBS sky130_fd_pr__nfet_01v8 ad=3.36 pd=8 as=3.12 ps=7.6 w=1.2 l=0.6
X2 out_n out_p tail VSUBS sky130_fd_pr__nfet_01v8 ad=3.36 pd=8 as=3.12 ps=7.6 w=1.2 l=0.6
X3 out_p sense_p tail VSUBS sky130_fd_pr__nfet_01v8 ad=3.36 pd=8 as=3.12 ps=7.6 w=1.2 l=0.6
C0 out_n out_p 0.74418f
C1 tail out_n 1.79756f
C2 sense_n out_p 0.00703f
C3 tail sense_n 0.1962f
C4 tail out_p 1.89733f
C5 out_p sense_p 0.04035f
C6 tail sense_p 0.18959f
C7 out_n sense_n 0.04664f
C8 tail VSUBS 19.18203f
C9 out_n VSUBS 7.10014f
C10 out_p VSUBS 0.98136f
.ends
