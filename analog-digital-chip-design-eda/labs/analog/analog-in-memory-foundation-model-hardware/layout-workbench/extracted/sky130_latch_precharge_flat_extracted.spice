* NGSPICE file created from sky130_latch_precharge_flat.ext - technology: sky130A

.subckt sky130_latch_precharge_flat out_p out_n sense_p sense_n tail reset vdd
X0 out_p out_n tail VSUBS sky130_fd_pr__nfet_01v8 ad=3.36 pd=8 as=3.12 ps=7.6 w=1.2 l=0.6
X1 out_n sense_n tail VSUBS sky130_fd_pr__nfet_01v8 ad=3.36 pd=8 as=3.12 ps=7.6 w=1.2 l=0.6
X2 out_n out_p tail VSUBS sky130_fd_pr__nfet_01v8 ad=3.36 pd=8 as=3.12 ps=7.6 w=1.2 l=0.6
X3 out_n reset vdd w_12400_300# sky130_fd_pr__pfet_01v8 ad=3.36 pd=8 as=3.12 ps=7.6 w=1.2 l=0.6
X4 out_p sense_p tail VSUBS sky130_fd_pr__nfet_01v8 ad=3.36 pd=8 as=3.12 ps=7.6 w=1.2 l=0.6
X5 out_p reset vdd w_12400_300# sky130_fd_pr__pfet_01v8 ad=3.36 pd=8 as=3.12 ps=7.6 w=1.2 l=0.6
C0 reset out_n 0.05967f
C1 vdd reset 0.20878f
C2 out_p tail 1.89751f
C3 w_12400_300# reset 4.03573f
C4 sense_n out_p 0.00703f
C5 sense_n tail 0.1962f
C6 out_p out_n 1.3877f
C7 vdd out_p 0.28588f
C8 tail out_n 1.7982f
C9 out_p w_12400_300# 0.76428f
C10 sense_n out_n 0.04664f
C11 sense_p out_p 0.04035f
C12 vdd out_n 0.07263f
C13 sense_p tail 0.18959f
C14 w_12400_300# out_n 0.70572f
C15 vdd w_12400_300# 1.53672f
C16 out_p reset 0.07615f
C17 vdd VSUBS 0.90789f
C18 tail VSUBS 27.15581f
C19 out_n VSUBS 12.39799f
C20 out_p VSUBS 0.98136f
C21 w_12400_300# VSUBS 30f
.ends
