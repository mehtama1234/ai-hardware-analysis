* NGSPICE file created from sky130_leaky_frontend_resistor_wrapper.ext - technology: sky130A

.subckt sky130_leaky_frontend_resistor_wrapper vss vdd sample_p sense_p clk_sample
+ vcm_reset clk_latch sense_n sample_n float_cm
X0 ultra_sample_n_sense_n_region float_cm VSUBS sky130_fd_pr__res_xhigh_po w=1.38 l=65.16
X1 ultra_sample_p_sense_p_region float_cm VSUBS sky130_fd_pr__res_xhigh_po w=1.38 l=65.16
X2 symmetric_latch_clock_region float_cm VSUBS sky130_fd_pr__res_xhigh_po w=1.38 l=65.16
X3 symmetric_reset_region float_cm VSUBS sky130_fd_pr__res_xhigh_po w=1.38 l=65.16
C0 ultra_sample_n_sense_n_region clk_sample 0.00505f
C1 ultra_sample_p_sense_p_region_uq0 vcm_reset 0.45034f
C2 clk_latch vcm_reset 0.11875f
C3 vdd sense_n 0.19187f
C4 symmetric_latch_clock_region_uq0 ultra_sample_p_sense_p_region_uq0 0.323f
C5 clk_sample ultra_sample_p_sense_p_region_uq0 0.9312f
C6 vss sense_n 0.19187f
C7 symmetric_latch_clock_region_uq0 clk_latch 0.3771f
C8 clk_sample clk_latch 0.37695f
C9 sample_p ultra_sample_p_sense_p_region_uq0 1.54805f
C10 sense_p ultra_sample_p_sense_p_region_uq0 1.69399f
C11 symmetric_latch_clock_region_uq0 vcm_reset 0.46205f
C12 clk_sample vcm_reset 0.60048f
C13 symmetric_latch_clock_region_uq0 clk_sample 1.8166f
C14 vdd ultra_sample_p_sense_p_region_uq0 0.38822f
C15 vss ultra_sample_p_sense_p_region_uq0 0.14411f
C16 ultra_sample_p_sense_p_region_uq0 sense_n 1.70029f
C17 ultra_sample_p_sense_p_region ultra_sample_p_sense_p_region_uq0 0.00505f
C18 vdd clk_latch 0.23373f
C19 vss clk_latch 0.23373f
C20 vdd sample_n 0.18668f
C21 sample_p symmetric_latch_clock_region_uq0 0
C22 vss sample_n 0.18668f
C23 sense_p symmetric_latch_clock_region_uq0 0.00776f
C24 sense_n sample_n 0.8f
C25 vdd vcm_reset 0.23025f
C26 vss vcm_reset 0.23025f
C27 vdd symmetric_latch_clock_region_uq0 0.11611f
C28 vdd clk_sample 0.37942f
C29 vss symmetric_latch_clock_region_uq0 0.06122f
C30 vss clk_sample 0.23373f
C31 symmetric_latch_clock_region_uq0 symmetric_reset_region 0.00925f
C32 sense_p sample_p 0.8f
C33 ultra_sample_p_sense_p_region_uq0 clk_latch 0.36501f
C34 vdd sample_p 0.18668f
C35 sample_p vss 0.18668f
C36 vdd sense_p 0.19187f
C37 sense_p vss 0.19187f
C38 ultra_sample_p_sense_p_region_uq0 sample_n 1.54842f
C39 sample_n VSUBS 0.60102f
C40 sense_n VSUBS 0.40539f
C41 clk_latch VSUBS 0.78869f
C42 vcm_reset VSUBS 0.499f
C43 sense_p VSUBS 0.40475f
C44 sample_p VSUBS 0.60102f
C45 vss VSUBS 3.07756f
C46 clk_sample VSUBS 4.11262f
C47 vdd VSUBS 3.08427f
C48 float_cm VSUBS 16.6326f
C49 symmetric_latch_clock_region_uq0 VSUBS 6.46359f ; **FLOATING
C50 ultra_sample_p_sense_p_region_uq0 VSUBS 9.85372f ; **FLOATING
C51 ultra_sample_p_sense_p_region VSUBS 4.36805f
C52 ultra_sample_n_sense_n_region VSUBS 4.72566f
C53 symmetric_reset_region VSUBS 5.07824f
C54 symmetric_latch_clock_region VSUBS 5.27445f
.ends
