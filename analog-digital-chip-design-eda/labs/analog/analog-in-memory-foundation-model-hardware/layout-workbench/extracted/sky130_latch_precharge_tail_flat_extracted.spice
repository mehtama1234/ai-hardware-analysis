* NGSPICE file created from sky130_latch_precharge_tail_flat.ext - technology: sky130A

.subckt sky130_latch_precharge_tail_flat out_p out_n sense_p sense_n tail reset vdd
+ vss eval
X0 out_p out_n tail VSUBS sky130_fd_pr__nfet_01v8 ad=3.36 pd=8 as=3.12 ps=7.6 w=1.2 l=0.6
X1 out_n sense_n tail VSUBS sky130_fd_pr__nfet_01v8 ad=3.36 pd=8 as=3.12 ps=7.6 w=1.2 l=0.6
X2 out_n out_p tail VSUBS sky130_fd_pr__nfet_01v8 ad=3.36 pd=8 as=3.12 ps=7.6 w=1.2 l=0.6
X3 out_n reset vdd w_12400_300# sky130_fd_pr__pfet_01v8 ad=3.36 pd=8 as=3.12 ps=7.6 w=1.2 l=0.6
X4 out_p sense_p tail VSUBS sky130_fd_pr__nfet_01v8 ad=3.36 pd=8 as=3.12 ps=7.6 w=1.2 l=0.6
X5 tail eval vss VSUBS sky130_fd_pr__nfet_01v8 ad=16.8 pd=17.6 as=15.6 ps=17.2 w=6 l=0.6
X6 out_p reset vdd w_12400_300# sky130_fd_pr__pfet_01v8 ad=3.36 pd=8 as=3.12 ps=7.6 w=1.2 l=0.6
C0 out_p w_12400_300# 0.76428f
C1 out_p sense_p 0.04035f
C2 reset out_n 0.05967f
C3 eval vss 0.04634f
C4 out_p eval 0.04062f
C5 sense_n tail 0.1962f
C6 out_n w_12400_300# 0.70572f
C7 out_p vss 0.1661f
C8 out_n eval 0.02298f
C9 out_n vss 0.06009f
C10 out_n out_p 1.2488f
C11 sense_n out_p 0.00703f
C12 out_n sense_n 0.04664f
C13 reset vdd 0.20878f
C14 w_12400_300# vdd 1.53672f
C15 sense_p tail 0.18959f
C16 eval tail 0.09415f
C17 reset w_12400_300# 4.03573f
C18 tail vss 0.19272f
C19 out_p tail 3.33055f
C20 out_p vdd 0.28588f
C21 out_n tail 2.28538f
C22 out_n vdd 0.07263f
C23 reset out_p 0.07615f
C24 vdd VSUBS 0.90789f
C25 out_n VSUBS 11.59099f
C26 out_p VSUBS 0.98136f
C27 tail VSUBS 29.38712f
C28 vss VSUBS 0.75002f
C29 w_12400_300# VSUBS 30f
.ends
