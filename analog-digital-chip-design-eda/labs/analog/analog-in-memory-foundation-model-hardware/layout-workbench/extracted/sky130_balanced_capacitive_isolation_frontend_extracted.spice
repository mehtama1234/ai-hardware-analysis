* NGSPICE file created from sky130_balanced_capacitive_isolation_frontend.ext - technology: sky130A

.subckt sky130_balanced_capacitive_isolation_frontend vss vdd sample_p sense_p clk_sample
+ vcm_reset clk_latch sense_n sample_n
C0 vss clk_sample 0.22652f
C1 sample_p vdd 0.23053f
C2 vcm_reset symmetric_latch_clock_region 0.36862f
C3 sense_n symmetric_latch_clock_region 0.00174f
C4 vss mirrored_sample_n_sense_n_region 0.02933f
C5 clk_sample vcm_reset 0.15476f
C6 vcm_reset symmetric_reset_region 0.36958f
C7 sense_n symmetric_reset_region 0.00199f
C8 mirrored_sample_n_sense_n_region vcm_reset 0
C9 sense_n mirrored_sample_n_sense_n_region 0.33886f
C10 vdd clk_sample 0.22748f
C11 sense_p mirrored_sample_p_sense_p_region 0.33886f
C12 vdd symmetric_reset_region 0.04616f
C13 vdd mirrored_sample_n_sense_n_region 0.01569f
C14 clk_latch symmetric_latch_clock_region 0.3313f
C15 vss vcm_reset 0.22331f
C16 sense_n vss 0.23185f
C17 sample_p mirrored_sample_p_sense_p_region 0.20106f
C18 clk_latch symmetric_reset_region 0.33225f
C19 mirrored_sample_n_sense_n_region clk_latch 0.00174f
C20 sample_p sense_p 0.08784f
C21 symmetric_latch_clock_region mirrored_sample_p_sense_p_region 0.00309f
C22 vdd vcm_reset 0.22427f
C23 sense_n vdd 0.23288f
C24 sense_p symmetric_latch_clock_region 0.00174f
C25 sample_n symmetric_latch_clock_region 0
C26 vss clk_latch 0.22738f
C27 clk_sample mirrored_sample_p_sense_p_region 0.00174f
C28 sense_p clk_sample 0.08784f
C29 sense_p symmetric_reset_region 0.00199f
C30 clk_latch vcm_reset 0.1413f
C31 sense_n clk_latch 0.08784f
C32 sample_p symmetric_latch_clock_region 0
C33 sample_n symmetric_reset_region 0
C34 sample_n mirrored_sample_n_sense_n_region 0.20106f
C35 vdd clk_latch 0.22833f
C36 vss mirrored_sample_p_sense_p_region 0.02933f
C37 vss sense_p 0.23185f
C38 sample_p symmetric_reset_region 0
C39 sample_n vss 0.23019f
C40 clk_sample symmetric_latch_clock_region 0.32993f
C41 vcm_reset mirrored_sample_p_sense_p_region 0
C42 symmetric_latch_clock_region symmetric_reset_region 0.04332f
C43 mirrored_sample_n_sense_n_region symmetric_latch_clock_region 0.00309f
C44 sample_n sense_n 0.08784f
C45 sample_p vss 0.23019f
C46 vdd mirrored_sample_p_sense_p_region 0.01569f
C47 clk_sample symmetric_reset_region 0.33089f
C48 vdd sense_p 0.23288f
C49 sample_n vdd 0.23053f
C50 vss symmetric_latch_clock_region 0.06258f
C51 sample_n VSUBS 0.81157f
C52 sense_n VSUBS 0.56146f
C53 clk_latch VSUBS 0.45919f
C54 vcm_reset VSUBS 0.34713f
C55 clk_sample VSUBS 0.45009f
C56 sense_p VSUBS 0.56146f
C57 sample_p VSUBS 0.81157f
C58 vss VSUBS 2.60429f
C59 vdd VSUBS 2.68887f
C60 mirrored_sample_n_sense_n_region VSUBS 0.58542f ; **FLOATING
C61 symmetric_latch_clock_region VSUBS 0.6777f ; **FLOATING
C62 mirrored_sample_p_sense_p_region VSUBS 0.58542f ; **FLOATING
C63 symmetric_reset_region VSUBS 0.7181f ; **FLOATING
.ends
